* NGSPICE file created from p1_m4.ext - technology: gf180mcuD

.subckt p1_m4
X0 a_590_2214# a_190_2122# a_102_2214# a_n36_n36# nfet_03v3 ad=1.76p pd=8.88u as=1.76p ps=8.88u w=4u l=2u
X1 a_590_150# a_190_58# a_102_150# a_n36_n36# nfet_03v3 ad=1.76p pd=8.88u as=1.76p ps=8.88u w=4u l=2u
X2 a_590_1182# a_190_1090# a_102_1182# a_n36_n36# nfet_03v3 ad=1.76p pd=8.88u as=1.76p ps=8.88u w=4u l=2u
X3 a_590_3246# a_190_3154# a_102_3246# a_n36_n36# nfet_03v3 ad=1.76p pd=8.88u as=1.76p ps=8.88u w=4u l=2u
.ends
