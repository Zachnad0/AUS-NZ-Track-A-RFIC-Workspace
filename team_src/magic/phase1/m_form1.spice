.subckt mtest D G S B
XM D G S B nfet_03v3 L=2u W=4u nf=1 m=4
.ends
