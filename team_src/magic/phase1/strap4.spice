.subckt t D G S B
X1 D G S B nfet_03v3 w=5u l=2u
X2 D G S B nfet_03v3 w=5u l=2u
X3 D G S B nfet_03v3 w=5u l=2u
X4 D G S B nfet_03v3 w=5u l=2u
.ends
