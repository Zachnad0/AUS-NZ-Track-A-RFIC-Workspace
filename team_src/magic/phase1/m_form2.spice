.subckt mtest D G S B
XM1 D G S B nfet_03v3 L=2u W=4u nf=1 m=1
XM2 D G S B nfet_03v3 L=2u W=4u nf=1 m=1
XM3 D G S B nfet_03v3 L=2u W=4u nf=1 m=1
XM4 D G S B nfet_03v3 L=2u W=4u nf=1 m=1
.ends
