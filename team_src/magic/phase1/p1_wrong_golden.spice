.subckt p1_pair
XMP DP GP SP BP pfet_03v3 L=2u W=50u nf=1 m=1
XMN DN GN SN BN nfet_03v3 L=8u W=10u nf=1 m=1
.ends p1_pair
