* NGSPICE file created from p1_pair.ext - technology: gf180mcuD

.subckt p1_pair
X0 a_2590_150# a_2190_58# a_2102_150# w_1940_n60# pfet_03v3 ad=4.4p pd=20.88u as=4.4p ps=20.88u w=10u l=2u
X1 a_590_150# a_190_58# a_102_150# a_n36_n36# nfet_03v3 ad=4.4p pd=20.88u as=4.4p ps=20.88u w=10u l=2u
.ends
