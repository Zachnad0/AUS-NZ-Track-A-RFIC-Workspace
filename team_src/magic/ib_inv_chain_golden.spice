.subckt ib_inv_chain G1 S1 S2 S3 VDD VSS
XMIP1 S1 G1 VDD VDD pfet_03v3 L=0.3u W=10u nf=1 m=1
XMIN1 S1 G1 VSS VSS nfet_03v3 L=0.3u W=4u nf=1 m=1
XMIP2 S2 S1 VDD VDD pfet_03v3 L=0.3u W=26u nf=1 m=1
XMIN2 S2 S1 VSS VSS nfet_03v3 L=0.3u W=11u nf=1 m=1
XMIP3 S3 S2 VDD VDD pfet_03v3 L=0.3u W=44u nf=1 m=1
XMIN3 S3 S2 VSS VSS nfet_03v3 L=0.3u W=16u nf=1 m=1
.ends ib_inv_chain
