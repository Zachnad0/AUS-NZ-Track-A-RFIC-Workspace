.subckt ib_pl1test VDD D G
XMT D G VDD VDD pfet_03v3 L=1u W=16u nf=1 m=12
.ends ib_pl1test
