.subckt ib_l1test S D G
XMT D G S S nfet_03v3 L=1u W=4u nf=1 m=5
.ends ib_l1test
