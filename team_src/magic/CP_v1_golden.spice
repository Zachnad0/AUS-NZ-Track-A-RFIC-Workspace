* CP_v1 -- LVS golden netlist for the charge-pump layout (Aug-14, full-custom analog)
* 8 transistors. PARTITION DECIDED (Greg, 2026-08-05): TWO CURRENT PORTS into the
* block -- VGP feeds diode ref M_PREF, VGN feeds diode ref M_NREF -- both driven by
* the chip-level IBIAS generator (block ports, NOT pads; pin count unaffected). The
* schematic's ideal I_CP=50uA sources (I_PREF/I_NREF) are NOT laid out; the IBIAS
* generator sinks I_CP from VGP and sources I_CP into VGN externally. Devices are
* UNCHANGED from the characterized CP_v1; only the port list differs (VGP/VGN exposed).
.subckt CP_v1 UP DOWN CP_OUT VDD VSS VGP VGN
* --- PMOS current mirror (sources I_CP when UP) --- MATCH M_PREF <-> M_PSRC
XM_PREF VGP  VGP  VDD VDD pfet_03v3 L=2u   W=50u  nf=1  m=1
XM_PSRC PMID VGP  VDD VDD pfet_03v3 L=2u   W=50u  nf=1  m=1
XM_PSW  CP_OUT UP_B PMID VDD pfet_03v3 L=0.3u W=50u nf=1 m=1
* --- NMOS current mirror (sinks I_CP when DOWN) --- MATCH M_NREF <-> M_NSNK
XM_NREF VGN  VGN  VSS VSS nfet_03v3 L=2u   W=10u  nf=1  m=1
XM_NSNK NMID VGN  VSS VSS nfet_03v3 L=2u   W=10u  nf=1  m=1
XM_NSW  CP_OUT DOWN NMID VSS nfet_03v3 L=0.3u W=10u nf=1 m=1
* --- UP inverter (UP -> UP_B for the pmos switch) ---
XM_INVP UP_B UP VDD VDD pfet_03v3 L=0.3u W=2u nf=1 m=1
XM_INVN UP_B UP VSS VSS nfet_03v3 L=0.3u W=1u nf=1 m=1
.ends CP_v1
