* SPICE3 file created from vco_inductor_v2.ext - technology: gf180mcuD

.option scale=5n

X0 PORT2 m4_n14800_800# tm11k r_width=1600 r_length=15200
X1 m4_n14800_800# PORT1 tm11k r_width=1600 r_length=15200
C0 PORT1 m4_n14800_800# 7.46091f
C1 m4_n14800_800# m5_n1200_10400# 3.21608f
C2 m4_n14800_800# m5_n22400_10400# 3.21608f
C3 m4_n14800_800# PORT2 7.46091f
C4 PORT2 VSUBS 6.15034f
C5 PORT1 VSUBS 6.15034f
C6 m5_n1200_10400# VSUBS 6.6891f
C7 m5_n22400_10400# VSUBS 6.6891f
C8 m4_n14800_800# VSUBS 70.1544f **FLOATING
