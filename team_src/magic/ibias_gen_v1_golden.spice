* ibias_gen_v1 -- LVS golden, netlisted from team_src/xschem/ibias_gen_v1.sch (2026-08-14).
* Wide-swing cascode bias generator. NMOS mirror gate=NB, cascode gate=IBIAS (L=1u);
* PMOS mirror gate=PB, cascode gate=PA/VBCPD (L=1u). Currents scale by unit count m
* (unit nfet W=4u, unit pfet W=16u). XCDEC is the Vb_p(=PB) decap. XMN* legs feed the
* PFD/CP (VGP,VGN) and the DIV2 replica (IB_DIV2). Ports match the schematic .subckt.
.subckt ibias_gen_v1 IBIAS VGP VGN IB_DIV2 VDD VSS
XMN0   NB     NB     VSS VSS nfet_03v3 L=2u W=4u  nf=1 m=24
XMNC0  IBIAS  IBIAS  NB  VSS nfet_03v3 L=1u W=4u  nf=1 m=24
XMN1   n1     NB     VSS VSS nfet_03v3 L=2u W=4u  nf=1 m=5
XMNC1  VGP    IBIAS  n1  VSS nfet_03v3 L=1u W=4u  nf=1 m=5
XMN2   n2     NB     VSS VSS nfet_03v3 L=2u W=4u  nf=1 m=24
XMNC2  PA     IBIAS  n2  VSS nfet_03v3 L=1u W=4u  nf=1 m=24
XMNB   VBCPD  NB     VSS VSS nfet_03v3 L=2u W=4u  nf=1 m=2
XMP0   PB     PB     VDD VDD pfet_03v3 L=2u W=16u nf=1 m=24
XMP0c  PA     PA     PB  VDD pfet_03v3 L=1u W=16u nf=1 m=24
XMP1   p1     PB     VDD VDD pfet_03v3 L=2u W=16u nf=1 m=5
XMP1c  VGN    PA     p1  VDD pfet_03v3 L=1u W=16u nf=1 m=5
XMP2   p2     PB     VDD VDD pfet_03v3 L=2u W=16u nf=1 m=24
XMP2c  IB_DIV2 VBCPD p2  VDD pfet_03v3 L=1u W=16u nf=1 m=24
XMPB   pb2    pb2    VDD VDD pfet_03v3 L=2u W=16u nf=1 m=2
XMPBc  VBCPD  VBCPD  pb2 VDD pfet_03v3 L=1u W=16u nf=1 m=2
XCDEC  VDD    PB     VDD VDD pfet_03v3 L=2u W=16u nf=1 m=6
* Layout matching device (not in the schematic): the two NMOS end dummies on the
* 24:5 ratio array, tied off (gate->NB, S/D->VSS), netgen-merged to m=4. Added as a
* tied-off instance per the CP_v1/ib_nmos precedent so LVS matches uniquely.
XMDUM  VSS    NB     VSS VSS nfet_03v3 L=2u W=4u  nf=1 m=4
.ends ibias_gen_v1
