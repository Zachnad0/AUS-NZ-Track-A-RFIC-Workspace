* ibias_gen_v1 op-point currents into CP-replica loads. Corner set by CORNER
* env via sed (typical/ff/ss). Reports VGP/VGN/DIV2 branch currents + supply.
.param fnoicor=0
.param sw_stat_global=0
.param sw_stat_mismatch=0
.param sw_mc_global=0
.param sw_mc_mismatch=0
.lib /foss/pdks/gf180mcuD/libs.tech/ngspice/sm141064.ngspice CORNER
.include /foss/designs/AUS-NZ-integration/team_src/sim/ibias/ibias_sub.spice

V_VDD VDD 0 3.3
I_BIAS VDD IBIAS 240u
X1 IBIAS VGP VGN IB_DIV2 VDD 0 ibias_gen_v1
XM_PREF_rep VGP VGP vgp_s VDD pfet_03v3 L=2u W=50u nf=1
V_VGP VDD vgp_s 0
XM_NREF_rep VGN VGN vgn_s 0 nfet_03v3 L=2u W=10u nf=1
V_VGN vgn_s 0 0
XM_BREF_rep IB_DIV2 IB_DIV2 ibd_s 0 nfet_03v3 L=1u W=4u nf=1
V_IBD ibd_s 0 0

.control
op
let i_vgp = abs(i(v_vgp))
let i_vgn = abs(i(v_vgn))
let i_ibd = abs(i(v_ibd))
let i_vdd = abs(i(v_vdd))
let addmm = (i_vgp - i_vgn)/((i_vgp+i_vgn)/2)*100
print i_vgp i_vgn i_ibd i_vdd addmm
.endc
.end
