** sch_path: /foss/designs/AUS-NZ-integration/team_src/xschem/vco_tb.sch
**.subckt vco_tb
R1 out_p out_n 50
V1 vdd GND 3.3
.save i(v1)
x1 vdd net1 net2 GND tune vss vco_v1
V2 tune GND 2.0
.save i(v2)
XM2 vsg vsg GND GND nfet_03v3 L=0.28u W=100u nf=1 ad='int((nf+1)/2) * W/nf * 0.18u' as='int((nf+2)/2) * W/nf * 0.18u' pd='2*int((nf+1)/2) * (W/nf + 0.18u)'
+ ps='2*int((nf+2)/2) * (W/nf + 0.18u)' nrd='0.18u / W' nrs='0.18u / W' sa=0 sb=0 sd=0 m=4
XM1 net3 vsg GND GND nfet_03v3 L=0.28u W=100u nf=1 ad='int((nf+1)/2) * W/nf * 0.18u' as='int((nf+2)/2) * W/nf * 0.18u' pd='2*int((nf+1)/2) * (W/nf + 0.18u)'
+ ps='2*int((nf+2)/2) * (W/nf + 0.18u)' nrd='0.18u / W' nrs='0.18u / W' sa=0 sb=0 sd=0 m=4
Viss_meas vss net3 0
.save i(viss_meas)
I0 GND vsg 1m
XM3 vdd net2 out_n out_n nfet_03v3 L=0.28u W=50u nf=1 ad='int((nf+1)/2) * W/nf * 0.18u' as='int((nf+2)/2) * W/nf * 0.18u' pd='2*int((nf+1)/2) * (W/nf + 0.18u)'
+ ps='2*int((nf+2)/2) * (W/nf + 0.18u)' nrd='0.18u / W' nrs='0.18u / W' sa=0 sb=0 sd=0 m=4
XM4 out_n vsg GND GND nfet_03v3 L=0.28u W=100u nf=1 ad='int((nf+1)/2) * W/nf * 0.18u' as='int((nf+2)/2) * W/nf * 0.18u' pd='2*int((nf+1)/2) * (W/nf + 0.18u)'
+ ps='2*int((nf+2)/2) * (W/nf + 0.18u)' nrd='0.18u / W' nrs='0.18u / W' sa=0 sb=0 sd=0 m=4
XM5 vdd net1 out_p out_p nfet_03v3 L=0.28u W=50u nf=1 ad='int((nf+1)/2) * W/nf * 0.18u' as='int((nf+2)/2) * W/nf * 0.18u' pd='2*int((nf+1)/2) * (W/nf + 0.18u)'
+ ps='2*int((nf+2)/2) * (W/nf + 0.18u)' nrd='0.18u / W' nrs='0.18u / W' sa=0 sb=0 sd=0 m=4
XM6 out_p vsg GND GND nfet_03v3 L=0.28u W=100u nf=1 ad='int((nf+1)/2) * W/nf * 0.18u' as='int((nf+2)/2) * W/nf * 0.18u' pd='2*int((nf+1)/2) * (W/nf + 0.18u)'
+ ps='2*int((nf+2)/2) * (W/nf + 0.18u)' nrd='0.18u / W' nrs='0.18u / W' sa=0 sb=0 sd=0 m=4
.ic v(net1)=0.01 v(net2)=-0.01
**** begin user architecture code

*.option keepopinfo
.option reltol=1e-5
.option method=gear
.option numparam jobs=4
.option bypass=0

.control
save all
set num_threads=2
tran 5p 40n uic
wrdata ctrl40.dat v(net1) v(net2) v(out_p) v(out_n) i(v1) i(viss_meas)
.endc

.include /foss/pdks/gf180mcuD/libs.tech/ngspice/design.ngspice
.lib /foss/pdks/gf180mcuD/libs.tech/ngspice/sm141064.ngspice typical
.lib /foss/pdks/gf180mcuD/libs.tech/ngspice/sm141064.ngspice res_typical
.lib /foss/pdks/gf180mcuD/libs.tech/ngspice/sm141064.ngspice moscap_typical

**** end user architecture code
**.ends

* expanding   symbol:  vco_v1.sym # of pins=6
** sym_path: /foss/designs/AUS-NZ-integration/team_src/xschem/vco_v1.sym
** sch_path: /foss/designs/AUS-NZ-integration/team_src/xschem/vco_v1.sch
* ---- DUT: team_src/magic/vco_v1_golden.spice (the netlist the layout is LVS'd to)
.subckt vco_v1 VDD OUT_p OUT_n GND TUNE ISS
XM1 OUT_p OUT_n ISS GND nfet_03v3 L=0.28u W=40u nf=1
XM4 OUT_n OUT_p ISS GND nfet_03v3 L=0.28u W=40u nf=1
XM2 OUT_p OUT_n VDD VDD pfet_03v3 L=0.28u W=70u nf=1
XM3 OUT_n OUT_p VDD VDD pfet_03v3 L=0.28u W=70u nf=1
XC1 cap_bias OUT_n cap_nmos_03v3_b c_width=5u c_length=5u m=21
XC4 cap_bias OUT_p cap_nmos_03v3_b c_width=5u c_length=5u m=21
X1 OUT_n OUT_p GND vco_inductor_v2
XR2 TUNE cap_bias GND ppolyf_u_1k r_width=1u r_length=15u
.ends

* expanding   symbol:  vco_inductor_v2.sym # of pins=3
** sym_path: /foss/designs/AUS-NZ-integration/team_src/xschem/vco_inductor_v2.sym
.include $UPRJ_ROOT/team_src/xschem/vco_inductor_v2.subckt
.GLOBAL GND
.end
