** sch_path: /foss/designs/AUS-NZ-integration/team_src/xschem/vco_tb.sch
**.subckt vco_tb
R1 out_p out_n 50
V1 vdd GND 3.3
.save i(v1)
x1 vdd net1 net2 GND tune vss vco_v1
V2 tune GND 2.0
.save i(v2)
XM2 vsg vsg GND GND nfet_03v3 L=0.28u W=100u nf=1 ad='int((nf+1)/2) * W/nf * 0.18u' as='int((nf+2)/2) * W/nf * 0.18u' pd='2*int((nf+1)/2) * (W/nf + 0.18u)'
+ ps='2*int((nf+2)/2) * (W/nf + 0.18u)' nrd='0.18u / W' nrs='0.18u / W' sa=0 sb=0 sd=0 m=4
XM1 net3 vsg GND GND nfet_03v3 L=0.28u W=100u nf=1 ad='int((nf+1)/2) * W/nf * 0.18u' as='int((nf+2)/2) * W/nf * 0.18u' pd='2*int((nf+1)/2) * (W/nf + 0.18u)'
+ ps='2*int((nf+2)/2) * (W/nf + 0.18u)' nrd='0.18u / W' nrs='0.18u / W' sa=0 sb=0 sd=0 m=4
Viss_meas vss net3 0
.save i(viss_meas)
I0 GND vsg 1m
XM3 vdd net2 out_n out_n nfet_03v3 L=0.28u W=50u nf=1 ad='int((nf+1)/2) * W/nf * 0.18u' as='int((nf+2)/2) * W/nf * 0.18u' pd='2*int((nf+1)/2) * (W/nf + 0.18u)'
+ ps='2*int((nf+2)/2) * (W/nf + 0.18u)' nrd='0.18u / W' nrs='0.18u / W' sa=0 sb=0 sd=0 m=4
XM4 out_n vsg GND GND nfet_03v3 L=0.28u W=100u nf=1 ad='int((nf+1)/2) * W/nf * 0.18u' as='int((nf+2)/2) * W/nf * 0.18u' pd='2*int((nf+1)/2) * (W/nf + 0.18u)'
+ ps='2*int((nf+2)/2) * (W/nf + 0.18u)' nrd='0.18u / W' nrs='0.18u / W' sa=0 sb=0 sd=0 m=4
XM5 vdd net1 out_p out_p nfet_03v3 L=0.28u W=50u nf=1 ad='int((nf+1)/2) * W/nf * 0.18u' as='int((nf+2)/2) * W/nf * 0.18u' pd='2*int((nf+1)/2) * (W/nf + 0.18u)'
+ ps='2*int((nf+2)/2) * (W/nf + 0.18u)' nrd='0.18u / W' nrs='0.18u / W' sa=0 sb=0 sd=0 m=4
XM6 out_p vsg GND GND nfet_03v3 L=0.28u W=100u nf=1 ad='int((nf+1)/2) * W/nf * 0.18u' as='int((nf+2)/2) * W/nf * 0.18u' pd='2*int((nf+1)/2) * (W/nf + 0.18u)'
+ ps='2*int((nf+2)/2) * (W/nf + 0.18u)' nrd='0.18u / W' nrs='0.18u / W' sa=0 sb=0 sd=0 m=4
.ic v(net1)=0.01 v(net2)=-0.01
**** begin user architecture code

*.option keepopinfo
.option reltol=1e-5
.option method=gear
.option numparam jobs=4
.option bypass=0

.control
save all
set num_threads=2
tran 5p 200n uic
wrdata r_final.dat v(net1) v(net2) v(out_p) v(out_n) i(v1) i(viss_meas)
.endc

.include /foss/pdks/gf180mcuD/libs.tech/ngspice/design.ngspice
.lib /foss/pdks/gf180mcuD/libs.tech/ngspice/sm141064.ngspice typical
.lib /foss/pdks/gf180mcuD/libs.tech/ngspice/sm141064.ngspice res_typical
.lib /foss/pdks/gf180mcuD/libs.tech/ngspice/sm141064.ngspice moscap_typical

**** end user architecture code
**.ends

* expanding   symbol:  vco_v1.sym # of pins=6
** sym_path: /foss/designs/AUS-NZ-integration/team_src/xschem/vco_v1.sym
** sch_path: /foss/designs/AUS-NZ-integration/team_src/xschem/vco_v1.sch
* ---- DUT: signoff/pex/vco_v1/vco_v1.pex.spice (R+C extracted) with the coil's
* ---- R/C-only representation swapped for the lumped model that carries the L.
.subckt vco_v1 VDD OUT_p OUT_n GND TUNE ISS
V_vsubs vco_inductor_v2_0/VSUBS GND 0
X_ind OUT_p OUT_n GND vco_inductor_v2
X0 vco_tune_r_0/TUNE.t0 vco_tune_r_0/cap_bias.t0 vco_tune_r_0/GND.t0 ppolyf_u_1k r_width=1u r_length=15u
X1 vco_varactors_0/cap_bias.t41 vco_varactors_0/OUT_n.t0 cap_nmos_03v3_b c_width=5u c_length=5u
X2 vco_varactors_0/cap_bias.t19 vco_varactors_0/OUT_p.t10 cap_nmos_03v3_b c_width=5u c_length=5u
X3 vco_varactors_0/cap_bias.t18 vco_varactors_0/OUT_p.t11 cap_nmos_03v3_b c_width=5u c_length=5u
X4 vco_varactors_0/cap_bias.t3 vco_varactors_0/OUT_n.t20 cap_nmos_03v3_b c_width=5u c_length=5u
X5 vco_varactors_0/cap_bias.t34 vco_varactors_0/OUT_n.t4 cap_nmos_03v3_b c_width=5u c_length=5u
X6 vco_varactors_0/cap_bias.t33 vco_varactors_0/OUT_n.t5 cap_nmos_03v3_b c_width=5u c_length=5u
X7 vco_varactors_0/cap_bias.t20 vco_varactors_0/OUT_p.t9 cap_nmos_03v3_b c_width=5u c_length=5u
X8 vco_varactors_0/cap_bias.t29 vco_varactors_0/OUT_n.t6 cap_nmos_03v3_b c_width=5u c_length=5u
X9 vco_varactors_0/cap_bias.t6 vco_varactors_0/OUT_p.t17 cap_nmos_03v3_b c_width=5u c_length=5u
X10 vco_varactors_0/cap_bias.t22 vco_varactors_0/OUT_n.t10 cap_nmos_03v3_b c_width=5u c_length=5u
X11 vco_varactors_0/cap_bias.t21 vco_varactors_0/OUT_n.t11 cap_nmos_03v3_b c_width=5u c_length=5u
X12 vco_varactors_0/cap_bias.t8 vco_varactors_0/OUT_p.t15 cap_nmos_03v3_b c_width=5u c_length=5u
X13 vco_varactors_0/cap_bias.t7 vco_varactors_0/OUT_p.t16 cap_nmos_03v3_b c_width=5u c_length=5u
X14 vco_varactors_0/cap_bias.t17 vco_varactors_0/OUT_n.t12 cap_nmos_03v3_b c_width=5u c_length=5u
X15 vco_varactors_0/cap_bias.t9 vco_varactors_0/OUT_n.t17 cap_nmos_03v3_b c_width=5u c_length=5u
X16 vco_varactors_0/cap_bias.t5 vco_varactors_0/OUT_n.t18 cap_nmos_03v3_b c_width=5u c_length=5u
X17 vco_varactors_0/cap_bias.t0 vco_varactors_0/OUT_p.t20 cap_nmos_03v3_b c_width=5u c_length=5u
X18 vco_varactors_0/cap_bias.t10 vco_varactors_0/OUT_n.t16 cap_nmos_03v3_b c_width=5u c_length=5u
X19 vco_varactors_0/cap_bias.t4 vco_varactors_0/OUT_n.t19 cap_nmos_03v3_b c_width=5u c_length=5u
X20 vco_varactors_0/cap_bias.t38 vco_varactors_0/OUT_p.t0 cap_nmos_03v3_b c_width=5u c_length=5u
X21 vco_varactors_0/cap_bias.t37 vco_varactors_0/OUT_p.t1 cap_nmos_03v3_b c_width=5u c_length=5u
X22 vco_varactors_0/cap_bias.t36 vco_varactors_0/OUT_p.t2 cap_nmos_03v3_b c_width=5u c_length=5u
X23 vco_varactors_0/cap_bias.t25 vco_varactors_0/OUT_p.t7 cap_nmos_03v3_b c_width=5u c_length=5u
X24 vco_varactors_0/cap_bias.t24 vco_varactors_0/OUT_p.t8 cap_nmos_03v3_b c_width=5u c_length=5u
X25 vco_varactors_0/cap_bias.t1 vco_varactors_0/OUT_p.t19 cap_nmos_03v3_b c_width=5u c_length=5u
X26 vco_varactors_0/cap_bias.t40 vco_varactors_0/OUT_n.t1 cap_nmos_03v3_b c_width=5u c_length=5u
X27 vco_varactors_0/cap_bias.t39 vco_varactors_0/OUT_n.t2 cap_nmos_03v3_b c_width=5u c_length=5u
X28 vco_varactors_0/cap_bias.t35 vco_varactors_0/OUT_n.t3 cap_nmos_03v3_b c_width=5u c_length=5u
X29 vco_varactors_0/cap_bias.t26 vco_varactors_0/OUT_p.t6 cap_nmos_03v3_b c_width=5u c_length=5u
X30 vco_varactors_0/cap_bias.t12 vco_varactors_0/OUT_p.t14 cap_nmos_03v3_b c_width=5u c_length=5u
X31 vco_varactors_0/cap_bias.t27 vco_varactors_0/OUT_n.t8 cap_nmos_03v3_b c_width=5u c_length=5u
X32 vco_varactors_0/cap_bias.t23 vco_varactors_0/OUT_n.t9 cap_nmos_03v3_b c_width=5u c_length=5u
X33 vco_varactors_0/cap_bias.t14 vco_varactors_0/OUT_p.t12 cap_nmos_03v3_b c_width=5u c_length=5u
X34 vco_varactors_0/cap_bias.t13 vco_varactors_0/OUT_p.t13 cap_nmos_03v3_b c_width=5u c_length=5u
X35 vco_varactors_0/cap_bias.t28 vco_varactors_0/OUT_n.t7 cap_nmos_03v3_b c_width=5u c_length=5u
X36 vco_varactors_0/cap_bias.t16 vco_varactors_0/OUT_n.t13 cap_nmos_03v3_b c_width=5u c_length=5u
X37 vco_varactors_0/cap_bias.t15 vco_varactors_0/OUT_n.t14 cap_nmos_03v3_b c_width=5u c_length=5u
X38 vco_varactors_0/cap_bias.t11 vco_varactors_0/OUT_n.t15 cap_nmos_03v3_b c_width=5u c_length=5u
X39 vco_varactors_0/cap_bias.t2 vco_varactors_0/OUT_p.t18 cap_nmos_03v3_b c_width=5u c_length=5u
X40 vco_varactors_0/cap_bias.t32 vco_varactors_0/OUT_p.t3 cap_nmos_03v3_b c_width=5u c_length=5u
X41 vco_varactors_0/cap_bias.t31 vco_varactors_0/OUT_p.t4 cap_nmos_03v3_b c_width=5u c_length=5u
X42 vco_varactors_0/cap_bias.t30 vco_varactors_0/OUT_p.t5 cap_nmos_03v3_b c_width=5u c_length=5u
X45 vco_core_0/OUT_n.t5 vco_core_0/OUT_p.t24 vco_core_0/ISS.t12 vco_core_0/GND.t10 nfet_03v3 ad=1.04p pd=4.52u as=1.76p ps=8.88u w=4u l=0.28u
X46 vco_core_0/ISS.t15 vco_core_0/OUT_p.t17 vco_core_0/OUT_n.t12 vco_core_0/GND.t17 nfet_03v3 ad=1.04p pd=4.52u as=1.04p ps=4.52u w=4u l=0.28u
X47 vco_core_0/OUT_p.t9 vco_core_0/OUT_n.t29 vco_core_0/VDD.t1 vco_core_0/VDD.t0 pfet_03v3 ad=3.64p pd=14.52u as=6.16p ps=28.88u w=14u l=0.28u
X48 vco_core_0/OUT_n.t11 vco_core_0/OUT_p.t18 vco_core_0/ISS.t7 vco_core_0/GND.t16 nfet_03v3 ad=1.04p pd=4.52u as=1.04p ps=4.52u w=4u l=0.28u
X49 vco_core_0/OUT_p.t0 vco_core_0/OUT_n.t25 vco_core_0/VDD.t9 vco_core_0/VDD.t8 pfet_03v3 ad=6.16p pd=28.88u as=3.64p ps=14.52u w=14u l=0.28u
X50 vco_core_0/OUT_p.t11 vco_core_0/OUT_n.t27 vco_core_0/VDD.t5 vco_core_0/VDD.t4 pfet_03v3 ad=3.64p pd=14.52u as=3.64p ps=14.52u w=14u l=0.28u
X51 vco_core_0/VDD.t7 vco_core_0/OUT_n.t26 vco_core_0/OUT_p.t5 vco_core_0/VDD.t6 pfet_03v3 ad=3.64p pd=14.52u as=3.64p ps=14.52u w=14u l=0.28u
X52 vco_core_0/OUT_p.t14 vco_core_0/OUT_n.t24 vco_core_0/ISS.t18 vco_core_0/GND.t0 nfet_03v3 ad=1.04p pd=4.52u as=1.76p ps=8.88u w=4u l=0.28u
X53 vco_core_0/OUT_n.t9 vco_core_0/OUT_p.t20 vco_core_0/ISS.t8 vco_core_0/GND.t14 nfet_03v3 ad=1.04p pd=4.52u as=1.04p ps=4.52u w=4u l=0.28u
X54 vco_core_0/ISS.t16 vco_core_0/OUT_n.t15 vco_core_0/OUT_p.t12 vco_core_0/GND.t9 nfet_03v3 ad=1.76p pd=8.88u as=1.04p ps=4.52u w=4u l=0.28u
X55 vco_core_0/VDD.t3 vco_core_0/OUT_n.t28 vco_core_0/OUT_p.t7 vco_core_0/VDD.t2 pfet_03v3 ad=3.64p pd=14.52u as=3.64p ps=14.52u w=14u l=0.28u
X56 vco_core_0/ISS.t3 vco_core_0/OUT_p.t21 vco_core_0/OUT_n.t8 vco_core_0/GND.t13 nfet_03v3 ad=1.04p pd=4.52u as=1.04p ps=4.52u w=4u l=0.28u
X57 vco_core_0/ISS.t9 vco_core_0/OUT_p.t19 vco_core_0/OUT_n.t10 vco_core_0/GND.t15 nfet_03v3 ad=1.04p pd=4.52u as=1.04p ps=4.52u w=4u l=0.28u
X58 vco_core_0/OUT_p.t13 vco_core_0/OUT_n.t16 vco_core_0/ISS.t17 vco_core_0/GND.t8 nfet_03v3 ad=1.04p pd=4.52u as=1.04p ps=4.52u w=4u l=0.28u
X59 vco_core_0/OUT_n.t3 vco_core_0/OUT_p.t27 vco_core_0/VDD.t15 vco_core_0/VDD.t14 pfet_03v3 ad=3.64p pd=14.52u as=3.64p ps=14.52u w=14u l=0.28u
X60 vco_core_0/ISS.t1 vco_core_0/OUT_n.t23 vco_core_0/OUT_p.t1 vco_core_0/GND.t1 nfet_03v3 ad=1.04p pd=4.52u as=1.04p ps=4.52u w=4u l=0.28u
X61 vco_core_0/OUT_n.t4 vco_core_0/OUT_p.t25 vco_core_0/VDD.t19 vco_core_0/VDD.t18 pfet_03v3 ad=6.16p pd=28.88u as=3.64p ps=14.52u w=14u l=0.28u
X62 vco_core_0/OUT_p.t10 vco_core_0/OUT_n.t22 vco_core_0/ISS.t13 vco_core_0/GND.t2 nfet_03v3 ad=1.04p pd=4.52u as=1.04p ps=4.52u w=4u l=0.28u
X63 vco_core_0/VDD.t13 vco_core_0/OUT_p.t28 vco_core_0/OUT_n.t1 vco_core_0/VDD.t12 pfet_03v3 ad=3.64p pd=14.52u as=3.64p ps=14.52u w=14u l=0.28u
X64 vco_core_0/VDD.t17 vco_core_0/OUT_p.t26 vco_core_0/OUT_n.t0 vco_core_0/VDD.t16 pfet_03v3 ad=3.64p pd=14.52u as=3.64p ps=14.52u w=14u l=0.28u
X65 vco_core_0/OUT_n.t7 vco_core_0/OUT_p.t22 vco_core_0/ISS.t4 vco_core_0/GND.t12 nfet_03v3 ad=1.04p pd=4.52u as=1.04p ps=4.52u w=4u l=0.28u
X66 vco_core_0/ISS.t6 vco_core_0/OUT_n.t19 vco_core_0/OUT_p.t4 vco_core_0/GND.t5 nfet_03v3 ad=1.04p pd=4.52u as=1.04p ps=4.52u w=4u l=0.28u
X67 vco_core_0/ISS.t11 vco_core_0/OUT_n.t17 vco_core_0/OUT_p.t8 vco_core_0/GND.t7 nfet_03v3 ad=1.04p pd=4.52u as=1.04p ps=4.52u w=4u l=0.28u
X68 vco_core_0/ISS.t19 vco_core_0/OUT_p.t23 vco_core_0/OUT_n.t6 vco_core_0/GND.t11 nfet_03v3 ad=1.04p pd=4.52u as=1.04p ps=4.52u w=4u l=0.28u
X69 vco_core_0/OUT_p.t3 vco_core_0/OUT_n.t18 vco_core_0/ISS.t5 vco_core_0/GND.t6 nfet_03v3 ad=1.04p pd=4.52u as=1.04p ps=4.52u w=4u l=0.28u
X70 vco_core_0/ISS.t0 vco_core_0/OUT_p.t15 vco_core_0/OUT_n.t14 vco_core_0/GND.t19 nfet_03v3 ad=1.76p pd=8.88u as=1.04p ps=4.52u w=4u l=0.28u
X71 vco_core_0/OUT_n.t13 vco_core_0/OUT_p.t16 vco_core_0/ISS.t14 vco_core_0/GND.t18 nfet_03v3 ad=1.04p pd=4.52u as=1.04p ps=4.52u w=4u l=0.28u
X72 vco_core_0/ISS.t2 vco_core_0/OUT_n.t21 vco_core_0/OUT_p.t2 vco_core_0/GND.t3 nfet_03v3 ad=1.04p pd=4.52u as=1.04p ps=4.52u w=4u l=0.28u
X73 vco_core_0/OUT_n.t2 vco_core_0/OUT_p.t29 vco_core_0/VDD.t11 vco_core_0/VDD.t10 pfet_03v3 ad=3.64p pd=14.52u as=6.16p ps=28.88u w=14u l=0.28u
X74 vco_core_0/OUT_p.t6 vco_core_0/OUT_n.t20 vco_core_0/ISS.t10 vco_core_0/GND.t4 nfet_03v3 ad=1.04p pd=4.52u as=1.04p ps=4.52u w=4u l=0.28u
C0 VDD OUT_n 10.00115f
C1 ISS OUT_p 4.02678f
C2 vco_tune_r_0/cap_bias OUT_n 39.83544f
C5 VDD OUT_p 10.13264f
C6 TUNE OUT_p 0.00194f
C7 VDD ISS 0
C8 vco_tune_r_0/cap_bias OUT_p 40.13977f
C9 ISS vco_tune_r_0/cap_bias 0.02028f
C10 OUT_p vco_inductor_v2_0/GND 0.19984f
C11 OUT_p OUT_n 10.73769f
C12 ISS OUT_n 4.07113f
R0 vco_tune_r_0/cap_bias vco_tune_r_0/cap_bias.t0 7.20993
R1 TUNE vco_tune_r_0/TUNE.t0 7.20993
R2 GND vco_tune_r_0/GND.t0 122.831
R3 vco_varactors_0/cap_bias.n95 vco_varactors_0/cap_bias.t40 9.3593
R4 vco_varactors_0/cap_bias.t40 vco_varactors_0/cap_bias.n13 9.3593
R5 vco_varactors_0/cap_bias.n86 vco_varactors_0/cap_bias.t39 9.3593
R6 vco_varactors_0/cap_bias.t39 vco_varactors_0/cap_bias.n24 9.3593
R7 vco_varactors_0/cap_bias.n77 vco_varactors_0/cap_bias.t38 9.3593
R8 vco_varactors_0/cap_bias.t38 vco_varactors_0/cap_bias.n35 9.3593
R9 vco_varactors_0/cap_bias.n68 vco_varactors_0/cap_bias.t37 9.3593
R10 vco_varactors_0/cap_bias.t37 vco_varactors_0/cap_bias.n46 9.3593
R11 vco_varactors_0/cap_bias.n110 vco_varactors_0/cap_bias.t41 9.3593
R12 vco_varactors_0/cap_bias.t41 vco_varactors_0/cap_bias.n109 9.3593
R13 vco_varactors_0/cap_bias.n58 vco_varactors_0/cap_bias.t36 9.3593
R14 vco_varactors_0/cap_bias.t36 vco_varactors_0/cap_bias.n57 9.3593
R15 vco_varactors_0/cap_bias.n8 vco_varactors_0/cap_bias.t4 5.13283
R16 vco_varactors_0/cap_bias.n19 vco_varactors_0/cap_bias.t3 5.13283
R17 vco_varactors_0/cap_bias.n30 vco_varactors_0/cap_bias.t2 5.13283
R18 vco_varactors_0/cap_bias.n41 vco_varactors_0/cap_bias.t1 5.13283
R19 vco_varactors_0/cap_bias.n104 vco_varactors_0/cap_bias.t5 5.13283
R20 vco_varactors_0/cap_bias.n52 vco_varactors_0/cap_bias.t0 5.13283
R21 vco_varactors_0/cap_bias.n12 vco_varactors_0/cap_bias.t34 4.57842
R22 vco_varactors_0/cap_bias.n11 vco_varactors_0/cap_bias.t28 4.57842
R23 vco_varactors_0/cap_bias.n10 vco_varactors_0/cap_bias.t22 4.57842
R24 vco_varactors_0/cap_bias.n9 vco_varactors_0/cap_bias.t16 4.57842
R25 vco_varactors_0/cap_bias.n8 vco_varactors_0/cap_bias.t10 4.57842
R26 vco_varactors_0/cap_bias.n23 vco_varactors_0/cap_bias.t33 4.57842
R27 vco_varactors_0/cap_bias.n22 vco_varactors_0/cap_bias.t27 4.57842
R28 vco_varactors_0/cap_bias.n21 vco_varactors_0/cap_bias.t21 4.57842
R29 vco_varactors_0/cap_bias.n20 vco_varactors_0/cap_bias.t15 4.57842
R30 vco_varactors_0/cap_bias.n19 vco_varactors_0/cap_bias.t9 4.57842
R31 vco_varactors_0/cap_bias.n34 vco_varactors_0/cap_bias.t32 4.57842
R32 vco_varactors_0/cap_bias.n33 vco_varactors_0/cap_bias.t26 4.57842
R33 vco_varactors_0/cap_bias.n32 vco_varactors_0/cap_bias.t20 4.57842
R34 vco_varactors_0/cap_bias.n31 vco_varactors_0/cap_bias.t14 4.57842
R35 vco_varactors_0/cap_bias.n30 vco_varactors_0/cap_bias.t8 4.57842
R36 vco_varactors_0/cap_bias.n45 vco_varactors_0/cap_bias.t31 4.57842
R37 vco_varactors_0/cap_bias.n44 vco_varactors_0/cap_bias.t25 4.57842
R38 vco_varactors_0/cap_bias.n43 vco_varactors_0/cap_bias.t19 4.57842
R39 vco_varactors_0/cap_bias.n42 vco_varactors_0/cap_bias.t13 4.57842
R40 vco_varactors_0/cap_bias.n41 vco_varactors_0/cap_bias.t7 4.57842
R41 vco_varactors_0/cap_bias.n108 vco_varactors_0/cap_bias.t35 4.57842
R42 vco_varactors_0/cap_bias.n107 vco_varactors_0/cap_bias.t29 4.57842
R43 vco_varactors_0/cap_bias.n106 vco_varactors_0/cap_bias.t23 4.57842
R44 vco_varactors_0/cap_bias.n105 vco_varactors_0/cap_bias.t17 4.57842
R45 vco_varactors_0/cap_bias.n104 vco_varactors_0/cap_bias.t11 4.57842
R46 vco_varactors_0/cap_bias.n56 vco_varactors_0/cap_bias.t30 4.57842
R47 vco_varactors_0/cap_bias.n55 vco_varactors_0/cap_bias.t24 4.57842
R48 vco_varactors_0/cap_bias.n54 vco_varactors_0/cap_bias.t18 4.57842
R49 vco_varactors_0/cap_bias.n53 vco_varactors_0/cap_bias.t12 4.57842
R50 vco_varactors_0/cap_bias.n52 vco_varactors_0/cap_bias.t6 4.57842
R51 vco_varactors_0/cap_bias.n65 vco_varactors_0/cap_bias.n50 4.5005
R52 vco_varactors_0/cap_bias.n65 vco_varactors_0/cap_bias.n48 4.5005
R53 vco_varactors_0/cap_bias.n65 vco_varactors_0/cap_bias.n64 4.5005
R54 vco_varactors_0/cap_bias.n64 vco_varactors_0/cap_bias.n63 4.5005
R55 vco_varactors_0/cap_bias.n74 vco_varactors_0/cap_bias.n39 4.5005
R56 vco_varactors_0/cap_bias.n74 vco_varactors_0/cap_bias.n37 4.5005
R57 vco_varactors_0/cap_bias.n47 vco_varactors_0/cap_bias.n37 4.5005
R58 vco_varactors_0/cap_bias.n74 vco_varactors_0/cap_bias.n73 4.5005
R59 vco_varactors_0/cap_bias.n73 vco_varactors_0/cap_bias.n47 4.5005
R60 vco_varactors_0/cap_bias.n73 vco_varactors_0/cap_bias.n72 4.5005
R61 vco_varactors_0/cap_bias.n83 vco_varactors_0/cap_bias.n28 4.5005
R62 vco_varactors_0/cap_bias.n83 vco_varactors_0/cap_bias.n26 4.5005
R63 vco_varactors_0/cap_bias.n36 vco_varactors_0/cap_bias.n26 4.5005
R64 vco_varactors_0/cap_bias.n83 vco_varactors_0/cap_bias.n82 4.5005
R65 vco_varactors_0/cap_bias.n82 vco_varactors_0/cap_bias.n36 4.5005
R66 vco_varactors_0/cap_bias.n82 vco_varactors_0/cap_bias.n81 4.5005
R67 vco_varactors_0/cap_bias.n92 vco_varactors_0/cap_bias.n17 4.5005
R68 vco_varactors_0/cap_bias.n92 vco_varactors_0/cap_bias.n15 4.5005
R69 vco_varactors_0/cap_bias.n25 vco_varactors_0/cap_bias.n15 4.5005
R70 vco_varactors_0/cap_bias.n92 vco_varactors_0/cap_bias.n91 4.5005
R71 vco_varactors_0/cap_bias.n91 vco_varactors_0/cap_bias.n25 4.5005
R72 vco_varactors_0/cap_bias.n91 vco_varactors_0/cap_bias.n90 4.5005
R73 vco_varactors_0/cap_bias.n101 vco_varactors_0/cap_bias.n6 4.5005
R74 vco_varactors_0/cap_bias.n101 vco_varactors_0/cap_bias.n4 4.5005
R75 vco_varactors_0/cap_bias.n14 vco_varactors_0/cap_bias.n4 4.5005
R76 vco_varactors_0/cap_bias.n101 vco_varactors_0/cap_bias.n100 4.5005
R77 vco_varactors_0/cap_bias.n100 vco_varactors_0/cap_bias.n14 4.5005
R78 vco_varactors_0/cap_bias.n100 vco_varactors_0/cap_bias.n99 4.5005
R79 vco_varactors_0/cap_bias.n112 vco_varactors_0/cap_bias.n111 4.5005
R80 vco_varactors_0/cap_bias.n113 vco_varactors_0/cap_bias.n112 4.5005
R81 vco_varactors_0/cap_bias.n2 vco_varactors_0/cap_bias.n0 4.5005
R82 vco_varactors_0/cap_bias.n112 vco_varactors_0/cap_bias.n2 4.5005
R83 vco_varactors_0/cap_bias.n103 vco_varactors_0/cap_bias.n1 2.31457
R84 vco_varactors_0/cap_bias.n60 vco_varactors_0/cap_bias.n59 2.31457
R85 vco_varactors_0/cap_bias.n111 vco_varactors_0/cap_bias.n1 2.2505
R86 vco_varactors_0/cap_bias.n60 vco_varactors_0/cap_bias.n50 2.2505
R87 vco_varactors_0/cap_bias.n59 vco_varactors_0/cap_bias.n49 2.24511
R88 vco_varactors_0/cap_bias.n69 vco_varactors_0/cap_bias.n38 2.24511
R89 vco_varactors_0/cap_bias.n70 vco_varactors_0/cap_bias.n69 2.24511
R90 vco_varactors_0/cap_bias.n66 vco_varactors_0/cap_bias.n39 2.24511
R91 vco_varactors_0/cap_bias.n78 vco_varactors_0/cap_bias.n27 2.24511
R92 vco_varactors_0/cap_bias.n79 vco_varactors_0/cap_bias.n78 2.24511
R93 vco_varactors_0/cap_bias.n75 vco_varactors_0/cap_bias.n28 2.24511
R94 vco_varactors_0/cap_bias.n87 vco_varactors_0/cap_bias.n16 2.24511
R95 vco_varactors_0/cap_bias.n88 vco_varactors_0/cap_bias.n87 2.24511
R96 vco_varactors_0/cap_bias.n84 vco_varactors_0/cap_bias.n17 2.24511
R97 vco_varactors_0/cap_bias.n96 vco_varactors_0/cap_bias.n5 2.24511
R98 vco_varactors_0/cap_bias.n97 vco_varactors_0/cap_bias.n96 2.24511
R99 vco_varactors_0/cap_bias.n93 vco_varactors_0/cap_bias.n6 2.24511
R100 vco_varactors_0/cap_bias.n103 vco_varactors_0/cap_bias.n102 2.24511
R101 vco_varactors_0/cap_bias.n63 vco_varactors_0/cap_bias.n62 2.24503
R102 vco_varactors_0/cap_bias.n72 vco_varactors_0/cap_bias.n71 2.24503
R103 vco_varactors_0/cap_bias.n67 vco_varactors_0/cap_bias.n40 2.24503
R104 vco_varactors_0/cap_bias.n81 vco_varactors_0/cap_bias.n80 2.24503
R105 vco_varactors_0/cap_bias.n76 vco_varactors_0/cap_bias.n29 2.24503
R106 vco_varactors_0/cap_bias.n90 vco_varactors_0/cap_bias.n89 2.24503
R107 vco_varactors_0/cap_bias.n85 vco_varactors_0/cap_bias.n18 2.24503
R108 vco_varactors_0/cap_bias.n99 vco_varactors_0/cap_bias.n98 2.24503
R109 vco_varactors_0/cap_bias.n94 vco_varactors_0/cap_bias.n7 2.24503
R110 vco_varactors_0/cap_bias.n3 vco_varactors_0/cap_bias.n0 2.24503
R111 vco_varactors_0/cap_bias.n115 vco_varactors_0/cap_bias.n114 1.16788
R112 vco_varactors_0/cap_bias.n61 vco_varactors_0/cap_bias.n51 1.16788
R113 vco_varactors_0/cap_bias.n12 vco_varactors_0/cap_bias.n11 0.554912
R114 vco_varactors_0/cap_bias.n11 vco_varactors_0/cap_bias.n10 0.554912
R115 vco_varactors_0/cap_bias.n10 vco_varactors_0/cap_bias.n9 0.554912
R116 vco_varactors_0/cap_bias.n9 vco_varactors_0/cap_bias.n8 0.554912
R117 vco_varactors_0/cap_bias.n23 vco_varactors_0/cap_bias.n22 0.554912
R118 vco_varactors_0/cap_bias.n22 vco_varactors_0/cap_bias.n21 0.554912
R119 vco_varactors_0/cap_bias.n21 vco_varactors_0/cap_bias.n20 0.554912
R120 vco_varactors_0/cap_bias.n20 vco_varactors_0/cap_bias.n19 0.554912
R121 vco_varactors_0/cap_bias.n34 vco_varactors_0/cap_bias.n33 0.554912
R122 vco_varactors_0/cap_bias.n33 vco_varactors_0/cap_bias.n32 0.554912
R123 vco_varactors_0/cap_bias.n32 vco_varactors_0/cap_bias.n31 0.554912
R124 vco_varactors_0/cap_bias.n31 vco_varactors_0/cap_bias.n30 0.554912
R125 vco_varactors_0/cap_bias.n45 vco_varactors_0/cap_bias.n44 0.554912
R126 vco_varactors_0/cap_bias.n44 vco_varactors_0/cap_bias.n43 0.554912
R127 vco_varactors_0/cap_bias.n43 vco_varactors_0/cap_bias.n42 0.554912
R128 vco_varactors_0/cap_bias.n42 vco_varactors_0/cap_bias.n41 0.554912
R129 vco_varactors_0/cap_bias.n108 vco_varactors_0/cap_bias.n107 0.554912
R130 vco_varactors_0/cap_bias.n107 vco_varactors_0/cap_bias.n106 0.554912
R131 vco_varactors_0/cap_bias.n106 vco_varactors_0/cap_bias.n105 0.554912
R132 vco_varactors_0/cap_bias.n105 vco_varactors_0/cap_bias.n104 0.554912
R133 vco_varactors_0/cap_bias.n56 vco_varactors_0/cap_bias.n55 0.554912
R134 vco_varactors_0/cap_bias.n55 vco_varactors_0/cap_bias.n54 0.554912
R135 vco_varactors_0/cap_bias.n54 vco_varactors_0/cap_bias.n53 0.554912
R136 vco_varactors_0/cap_bias.n53 vco_varactors_0/cap_bias.n52 0.554912
R137 vco_varactors_0/cap_bias.n13 vco_varactors_0/cap_bias.n12 0.350456
R138 vco_varactors_0/cap_bias.n24 vco_varactors_0/cap_bias.n23 0.350456
R139 vco_varactors_0/cap_bias.n35 vco_varactors_0/cap_bias.n34 0.350456
R140 vco_varactors_0/cap_bias.n46 vco_varactors_0/cap_bias.n45 0.350456
R141 vco_varactors_0/cap_bias.n109 vco_varactors_0/cap_bias.n108 0.350456
R142 vco_varactors_0/cap_bias.n57 vco_varactors_0/cap_bias.n56 0.350456
R143 vco_varactors_0/cap_bias.n100 vco_varactors_0/cap_bias.n13 0.311114
R144 vco_varactors_0/cap_bias.n91 vco_varactors_0/cap_bias.n24 0.311114
R145 vco_varactors_0/cap_bias.n82 vco_varactors_0/cap_bias.n35 0.311114
R146 vco_varactors_0/cap_bias.n73 vco_varactors_0/cap_bias.n46 0.311114
R147 vco_varactors_0/cap_bias.n109 vco_varactors_0/cap_bias.n2 0.311114
R148 vco_varactors_0/cap_bias.n64 vco_varactors_0/cap_bias.n57 0.311114
R149 vco_varactors_0/cap_bias.n72 vco_varactors_0/cap_bias.n65 0.222125
R150 vco_varactors_0/cap_bias.n81 vco_varactors_0/cap_bias.n74 0.222125
R151 vco_varactors_0/cap_bias.n90 vco_varactors_0/cap_bias.n83 0.222125
R152 vco_varactors_0/cap_bias.n99 vco_varactors_0/cap_bias.n92 0.222125
R153 vco_varactors_0/cap_bias.n112 vco_varactors_0/cap_bias.n101 0.222125
R154 vco_varactors_0/cap_bias.n115 vco_varactors_0/cap_bias.n1 0.0325339
R155 vco_varactors_0/cap_bias.n61 vco_varactors_0/cap_bias.n60 0.0325339
R156 vco_varactors_0/cap_bias.n63 vco_varactors_0/cap_bias.n61 0.0235625
R157 vco_varactors_0/cap_bias.n96 vco_varactors_0/cap_bias.n95 0.0229051
R158 vco_varactors_0/cap_bias.n87 vco_varactors_0/cap_bias.n86 0.0229051
R159 vco_varactors_0/cap_bias.n78 vco_varactors_0/cap_bias.n77 0.0229051
R160 vco_varactors_0/cap_bias.n69 vco_varactors_0/cap_bias.n68 0.0229051
R161 vco_varactors_0/cap_bias.n110 vco_varactors_0/cap_bias.n103 0.0229051
R162 vco_varactors_0/cap_bias.n59 vco_varactors_0/cap_bias.n58 0.0229051
R163 vco_tune_r_0/cap_bias vco_varactors_0/cap_bias.n0 0.0201875
R164 vco_varactors_0/cap_bias.n114 vco_varactors_0/cap_bias.n2 0.0130667
R165 vco_varactors_0/cap_bias.n64 vco_varactors_0/cap_bias.n51 0.0130667
R166 vco_varactors_0/cap_bias.n98 vco_varactors_0/cap_bias.n6 0.0129303
R167 vco_varactors_0/cap_bias.n100 vco_varactors_0/cap_bias.n7 0.0129303
R168 vco_varactors_0/cap_bias.n89 vco_varactors_0/cap_bias.n17 0.0129303
R169 vco_varactors_0/cap_bias.n91 vco_varactors_0/cap_bias.n18 0.0129303
R170 vco_varactors_0/cap_bias.n80 vco_varactors_0/cap_bias.n28 0.0129303
R171 vco_varactors_0/cap_bias.n82 vco_varactors_0/cap_bias.n29 0.0129303
R172 vco_varactors_0/cap_bias.n71 vco_varactors_0/cap_bias.n39 0.0129303
R173 vco_varactors_0/cap_bias.n73 vco_varactors_0/cap_bias.n40 0.0129303
R174 vco_varactors_0/cap_bias.n113 vco_varactors_0/cap_bias.n3 0.0129303
R175 vco_varactors_0/cap_bias.n62 vco_varactors_0/cap_bias.n48 0.0129303
R176 vco_varactors_0/cap_bias.n62 vco_varactors_0/cap_bias.n50 0.0129303
R177 vco_varactors_0/cap_bias.n40 vco_varactors_0/cap_bias.n37 0.0129303
R178 vco_varactors_0/cap_bias.n71 vco_varactors_0/cap_bias.n37 0.0129303
R179 vco_varactors_0/cap_bias.n29 vco_varactors_0/cap_bias.n26 0.0129303
R180 vco_varactors_0/cap_bias.n80 vco_varactors_0/cap_bias.n26 0.0129303
R181 vco_varactors_0/cap_bias.n18 vco_varactors_0/cap_bias.n15 0.0129303
R182 vco_varactors_0/cap_bias.n89 vco_varactors_0/cap_bias.n15 0.0129303
R183 vco_varactors_0/cap_bias.n7 vco_varactors_0/cap_bias.n4 0.0129303
R184 vco_varactors_0/cap_bias.n98 vco_varactors_0/cap_bias.n4 0.0129303
R185 vco_varactors_0/cap_bias.n111 vco_varactors_0/cap_bias.n3 0.0129303
R186 vco_varactors_0/cap_bias.n63 vco_varactors_0/cap_bias.n49 0.0127816
R187 vco_varactors_0/cap_bias.n72 vco_varactors_0/cap_bias.n70 0.0127816
R188 vco_varactors_0/cap_bias.n66 vco_varactors_0/cap_bias.n47 0.0127816
R189 vco_varactors_0/cap_bias.n47 vco_varactors_0/cap_bias.n38 0.0127816
R190 vco_varactors_0/cap_bias.n81 vco_varactors_0/cap_bias.n79 0.0127816
R191 vco_varactors_0/cap_bias.n75 vco_varactors_0/cap_bias.n36 0.0127816
R192 vco_varactors_0/cap_bias.n36 vco_varactors_0/cap_bias.n27 0.0127816
R193 vco_varactors_0/cap_bias.n90 vco_varactors_0/cap_bias.n88 0.0127816
R194 vco_varactors_0/cap_bias.n84 vco_varactors_0/cap_bias.n25 0.0127816
R195 vco_varactors_0/cap_bias.n25 vco_varactors_0/cap_bias.n16 0.0127816
R196 vco_varactors_0/cap_bias.n99 vco_varactors_0/cap_bias.n97 0.0127816
R197 vco_varactors_0/cap_bias.n93 vco_varactors_0/cap_bias.n14 0.0127816
R198 vco_varactors_0/cap_bias.n14 vco_varactors_0/cap_bias.n5 0.0127816
R199 vco_varactors_0/cap_bias.n112 vco_varactors_0/cap_bias.n102 0.0127816
R200 vco_varactors_0/cap_bias.n65 vco_varactors_0/cap_bias.n49 0.0127816
R201 vco_varactors_0/cap_bias.n74 vco_varactors_0/cap_bias.n38 0.0127816
R202 vco_varactors_0/cap_bias.n70 vco_varactors_0/cap_bias.n67 0.0127816
R203 vco_varactors_0/cap_bias.n67 vco_varactors_0/cap_bias.n66 0.0127816
R204 vco_varactors_0/cap_bias.n83 vco_varactors_0/cap_bias.n27 0.0127816
R205 vco_varactors_0/cap_bias.n79 vco_varactors_0/cap_bias.n76 0.0127816
R206 vco_varactors_0/cap_bias.n76 vco_varactors_0/cap_bias.n75 0.0127816
R207 vco_varactors_0/cap_bias.n92 vco_varactors_0/cap_bias.n16 0.0127816
R208 vco_varactors_0/cap_bias.n88 vco_varactors_0/cap_bias.n85 0.0127816
R209 vco_varactors_0/cap_bias.n85 vco_varactors_0/cap_bias.n84 0.0127816
R210 vco_varactors_0/cap_bias.n101 vco_varactors_0/cap_bias.n5 0.0127816
R211 vco_varactors_0/cap_bias.n97 vco_varactors_0/cap_bias.n94 0.0127816
R212 vco_varactors_0/cap_bias.n94 vco_varactors_0/cap_bias.n93 0.0127816
R213 vco_varactors_0/cap_bias.n102 vco_varactors_0/cap_bias.n0 0.0127816
R214 vco_varactors_0/cap_bias.n114 vco_varactors_0/cap_bias.n113 0.0127326
R215 vco_varactors_0/cap_bias.n51 vco_varactors_0/cap_bias.n48 0.0127326
R216 vco_tune_r_0/cap_bias vco_varactors_0/cap_bias.n115 0.003875
R217 vco_varactors_0/cap_bias.n95 vco_varactors_0/cap_bias.n6 0.00201899
R218 vco_varactors_0/cap_bias.n86 vco_varactors_0/cap_bias.n17 0.00201899
R219 vco_varactors_0/cap_bias.n77 vco_varactors_0/cap_bias.n28 0.00201899
R220 vco_varactors_0/cap_bias.n68 vco_varactors_0/cap_bias.n39 0.00201899
R221 vco_varactors_0/cap_bias.n111 vco_varactors_0/cap_bias.n110 0.00201899
R222 vco_varactors_0/cap_bias.n58 vco_varactors_0/cap_bias.n50 0.00201899
R223 vco_varactors_0/OUT_p.n49 vco_varactors_0/OUT_p.n1 4.69945
R224 vco_varactors_0/OUT_p.n51 vco_varactors_0/OUT_p.n1 4.5005
R225 vco_varactors_0/OUT_p.n30 vco_varactors_0/OUT_p.n29 4.5005
R226 vco_varactors_0/OUT_p.n30 vco_varactors_0/OUT_p.n20 4.5005
R227 vco_varactors_0/OUT_p.n32 vco_varactors_0/OUT_p.n31 4.5005
R228 vco_varactors_0/OUT_p.n31 vco_varactors_0/OUT_p.n30 4.5005
R229 vco_varactors_0/OUT_p.n39 vco_varactors_0/OUT_p.n11 4.5005
R230 vco_varactors_0/OUT_p.n39 vco_varactors_0/OUT_p.n13 4.5005
R231 vco_varactors_0/OUT_p.n36 vco_varactors_0/OUT_p.n13 4.5005
R232 vco_varactors_0/OUT_p.n37 vco_varactors_0/OUT_p.n4 4.5005
R233 vco_varactors_0/OUT_p.n37 vco_varactors_0/OUT_p.n36 4.5005
R234 vco_varactors_0/OUT_p.n36 vco_varactors_0/OUT_p.n14 4.5005
R235 vco_varactors_0/OUT_p.n52 vco_varactors_0/OUT_p.n51 4.5005
R236 vco_varactors_0/OUT_p.n53 vco_varactors_0/OUT_p.n0 4.5005
R237 vco_varactors_0/OUT_p.n53 vco_varactors_0/OUT_p.n52 4.5005
R238 vco_varactors_0/OUT_p.n52 vco_varactors_0/OUT_p.n2 4.5005
R239 vco_varactors_0/OUT_p.n5 vco_varactors_0/OUT_p.t1 3.04268
R240 vco_varactors_0/OUT_p.n43 vco_varactors_0/OUT_p.t0 3.04268
R241 vco_varactors_0/OUT_p.n21 vco_varactors_0/OUT_p.t2 3.04268
R242 vco_varactors_0/OUT_p.n55 vco_varactors_0/OUT_p.n54 2.39321
R243 vco_varactors_0/OUT_p.n27 vco_varactors_0/OUT_p.n17 2.24511
R244 vco_varactors_0/OUT_p.n35 vco_varactors_0/OUT_p.n11 2.24511
R245 vco_varactors_0/OUT_p.n33 vco_varactors_0/OUT_p.n14 2.24511
R246 vco_varactors_0/OUT_p.n49 vco_varactors_0/OUT_p.n42 2.24511
R247 vco_varactors_0/OUT_p.n40 vco_varactors_0/OUT_p.n2 2.24511
R248 vco_varactors_0/OUT_p.n32 vco_varactors_0/OUT_p.n16 2.24507
R249 vco_varactors_0/OUT_p.n12 vco_varactors_0/OUT_p.n4 2.24507
R250 vco_varactors_0/OUT_p.n34 vco_varactors_0/OUT_p.n15 2.24507
R251 vco_varactors_0/OUT_p.n39 vco_varactors_0/OUT_p.n38 2.24507
R252 vco_varactors_0/OUT_p.n50 vco_varactors_0/OUT_p.n0 2.24507
R253 vco_varactors_0/OUT_p.n41 vco_varactors_0/OUT_p.n3 2.24507
R254 vco_varactors_0/OUT_p.n5 vco_varactors_0/OUT_p.t4 2.47914
R255 vco_varactors_0/OUT_p.n6 vco_varactors_0/OUT_p.t7 2.47914
R256 vco_varactors_0/OUT_p.n7 vco_varactors_0/OUT_p.t10 2.47914
R257 vco_varactors_0/OUT_p.n8 vco_varactors_0/OUT_p.t13 2.47914
R258 vco_varactors_0/OUT_p.n9 vco_varactors_0/OUT_p.t16 2.47914
R259 vco_varactors_0/OUT_p.n10 vco_varactors_0/OUT_p.t19 2.47914
R260 vco_varactors_0/OUT_p.n43 vco_varactors_0/OUT_p.t3 2.47914
R261 vco_varactors_0/OUT_p.n44 vco_varactors_0/OUT_p.t6 2.47914
R262 vco_varactors_0/OUT_p.n45 vco_varactors_0/OUT_p.t9 2.47914
R263 vco_varactors_0/OUT_p.n46 vco_varactors_0/OUT_p.t12 2.47914
R264 vco_varactors_0/OUT_p.n47 vco_varactors_0/OUT_p.t15 2.47914
R265 vco_varactors_0/OUT_p.n48 vco_varactors_0/OUT_p.t18 2.47914
R266 vco_varactors_0/OUT_p.n21 vco_varactors_0/OUT_p.t5 2.47914
R267 vco_varactors_0/OUT_p.n22 vco_varactors_0/OUT_p.t8 2.47914
R268 vco_varactors_0/OUT_p.n23 vco_varactors_0/OUT_p.t11 2.47914
R269 vco_varactors_0/OUT_p.n24 vco_varactors_0/OUT_p.t14 2.47914
R270 vco_varactors_0/OUT_p.n25 vco_varactors_0/OUT_p.t17 2.47914
R271 vco_varactors_0/OUT_p.n26 vco_varactors_0/OUT_p.t20 2.47914
R272 vco_varactors_0/OUT_p.n28 vco_varactors_0/OUT_p.n19 1.14883
R273 vco_varactors_0/OUT_p.n19 vco_varactors_0/OUT_p.n18 1.14864
R274 vco_varactors_0/OUT_p.n6 vco_varactors_0/OUT_p.n5 0.564047
R275 vco_varactors_0/OUT_p.n7 vco_varactors_0/OUT_p.n6 0.564047
R276 vco_varactors_0/OUT_p.n8 vco_varactors_0/OUT_p.n7 0.564047
R277 vco_varactors_0/OUT_p.n9 vco_varactors_0/OUT_p.n8 0.564047
R278 vco_varactors_0/OUT_p.n10 vco_varactors_0/OUT_p.n9 0.564047
R279 vco_varactors_0/OUT_p.n44 vco_varactors_0/OUT_p.n43 0.564047
R280 vco_varactors_0/OUT_p.n45 vco_varactors_0/OUT_p.n44 0.564047
R281 vco_varactors_0/OUT_p.n46 vco_varactors_0/OUT_p.n45 0.564047
R282 vco_varactors_0/OUT_p.n47 vco_varactors_0/OUT_p.n46 0.564047
R283 vco_varactors_0/OUT_p.n48 vco_varactors_0/OUT_p.n47 0.564047
R284 vco_varactors_0/OUT_p.n22 vco_varactors_0/OUT_p.n21 0.564047
R285 vco_varactors_0/OUT_p.n23 vco_varactors_0/OUT_p.n22 0.564047
R286 vco_varactors_0/OUT_p.n24 vco_varactors_0/OUT_p.n23 0.564047
R287 vco_varactors_0/OUT_p.n25 vco_varactors_0/OUT_p.n24 0.564047
R288 vco_varactors_0/OUT_p.n26 vco_varactors_0/OUT_p.n25 0.564047
R289 vco_varactors_0/OUT_p.n11 vco_varactors_0/OUT_p.n10 0.266749
R290 vco_varactors_0/OUT_p.n49 vco_varactors_0/OUT_p.n48 0.266749
R291 vco_varactors_0/OUT_p.n27 vco_varactors_0/OUT_p.n26 0.266749
R292 vco_varactors_0/OUT_p.n36 vco_varactors_0/OUT_p.n32 0.222125
R293 vco_varactors_0/OUT_p.n52 vco_varactors_0/OUT_p.n39 0.222125
R294 vco_varactors_0/OUT_p.n55 vco_varactors_0/OUT_p.n1 0.0999737
R295 vco_varactors_0/OUT_p.n39 vco_varactors_0/OUT_p.n4 0.024125
R296 OUT_p vco_varactors_0/OUT_p.n0 0.0190625
R297 vco_varactors_0/OUT_p.n28 vco_varactors_0/OUT_p.n27 0.0135504
R298 vco_varactors_0/OUT_p.n54 vco_varactors_0/OUT_p.n2 0.0131126
R299 vco_varactors_0/OUT_p.n29 vco_varactors_0/OUT_p.n28 0.0130967
R300 vco_varactors_0/OUT_p.n31 vco_varactors_0/OUT_p.n18 0.0129243
R301 vco_varactors_0/OUT_p.n13 vco_varactors_0/OUT_p.n12 0.0128555
R302 vco_varactors_0/OUT_p.n37 vco_varactors_0/OUT_p.n15 0.0128555
R303 vco_varactors_0/OUT_p.n38 vco_varactors_0/OUT_p.n14 0.0128555
R304 vco_varactors_0/OUT_p.n51 vco_varactors_0/OUT_p.n50 0.0128555
R305 vco_varactors_0/OUT_p.n53 vco_varactors_0/OUT_p.n3 0.0128555
R306 vco_varactors_0/OUT_p.n20 vco_varactors_0/OUT_p.n16 0.0128555
R307 vco_varactors_0/OUT_p.n29 vco_varactors_0/OUT_p.n16 0.0128555
R308 vco_varactors_0/OUT_p.n12 vco_varactors_0/OUT_p.n11 0.0128555
R309 vco_varactors_0/OUT_p.n15 vco_varactors_0/OUT_p.n13 0.0128555
R310 vco_varactors_0/OUT_p.n38 vco_varactors_0/OUT_p.n37 0.0128555
R311 vco_varactors_0/OUT_p.n50 vco_varactors_0/OUT_p.n49 0.0128555
R312 vco_varactors_0/OUT_p.n51 vco_varactors_0/OUT_p.n3 0.0128555
R313 vco_varactors_0/OUT_p.n30 vco_varactors_0/OUT_p.n17 0.0127816
R314 vco_varactors_0/OUT_p.n36 vco_varactors_0/OUT_p.n35 0.0127816
R315 vco_varactors_0/OUT_p.n33 vco_varactors_0/OUT_p.n4 0.0127816
R316 vco_varactors_0/OUT_p.n52 vco_varactors_0/OUT_p.n42 0.0127816
R317 vco_varactors_0/OUT_p.n40 vco_varactors_0/OUT_p.n0 0.0127816
R318 vco_varactors_0/OUT_p.n32 vco_varactors_0/OUT_p.n17 0.0127816
R319 vco_varactors_0/OUT_p.n35 vco_varactors_0/OUT_p.n34 0.0127816
R320 vco_varactors_0/OUT_p.n34 vco_varactors_0/OUT_p.n33 0.0127816
R321 vco_varactors_0/OUT_p.n42 vco_varactors_0/OUT_p.n41 0.0127816
R322 vco_varactors_0/OUT_p.n41 vco_varactors_0/OUT_p.n40 0.0127816
R323 vco_varactors_0/OUT_p.n20 vco_varactors_0/OUT_p.n18 0.0127254
R324 vco_varactors_0/OUT_p.n54 vco_varactors_0/OUT_p.n53 0.0125997
R325 OUT_p vco_varactors_0/OUT_p.n55 0.003875
R326 vco_varactors_0/OUT_p.n30 vco_varactors_0/OUT_p.n19 0.0010625
R327 vco_varactors_0/OUT_n.n49 vco_varactors_0/OUT_n.n1 4.69945
R328 vco_varactors_0/OUT_n.n51 vco_varactors_0/OUT_n.n1 4.5005
R329 vco_varactors_0/OUT_n.n30 vco_varactors_0/OUT_n.n29 4.5005
R330 vco_varactors_0/OUT_n.n30 vco_varactors_0/OUT_n.n20 4.5005
R331 vco_varactors_0/OUT_n.n32 vco_varactors_0/OUT_n.n31 4.5005
R332 vco_varactors_0/OUT_n.n31 vco_varactors_0/OUT_n.n30 4.5005
R333 vco_varactors_0/OUT_n.n39 vco_varactors_0/OUT_n.n11 4.5005
R334 vco_varactors_0/OUT_n.n39 vco_varactors_0/OUT_n.n13 4.5005
R335 vco_varactors_0/OUT_n.n36 vco_varactors_0/OUT_n.n13 4.5005
R336 vco_varactors_0/OUT_n.n37 vco_varactors_0/OUT_n.n4 4.5005
R337 vco_varactors_0/OUT_n.n37 vco_varactors_0/OUT_n.n36 4.5005
R338 vco_varactors_0/OUT_n.n36 vco_varactors_0/OUT_n.n14 4.5005
R339 vco_varactors_0/OUT_n.n52 vco_varactors_0/OUT_n.n51 4.5005
R340 vco_varactors_0/OUT_n.n53 vco_varactors_0/OUT_n.n0 4.5005
R341 vco_varactors_0/OUT_n.n53 vco_varactors_0/OUT_n.n52 4.5005
R342 vco_varactors_0/OUT_n.n52 vco_varactors_0/OUT_n.n2 4.5005
R343 vco_varactors_0/OUT_n.n5 vco_varactors_0/OUT_n.t1 3.04268
R344 vco_varactors_0/OUT_n.n43 vco_varactors_0/OUT_n.t0 3.04268
R345 vco_varactors_0/OUT_n.n21 vco_varactors_0/OUT_n.t2 3.04268
R346 vco_varactors_0/OUT_n.n55 vco_varactors_0/OUT_n.n54 2.39321
R347 vco_varactors_0/OUT_n.n27 vco_varactors_0/OUT_n.n17 2.24511
R348 vco_varactors_0/OUT_n.n35 vco_varactors_0/OUT_n.n11 2.24511
R349 vco_varactors_0/OUT_n.n33 vco_varactors_0/OUT_n.n14 2.24511
R350 vco_varactors_0/OUT_n.n49 vco_varactors_0/OUT_n.n42 2.24511
R351 vco_varactors_0/OUT_n.n40 vco_varactors_0/OUT_n.n2 2.24511
R352 vco_varactors_0/OUT_n.n32 vco_varactors_0/OUT_n.n16 2.24507
R353 vco_varactors_0/OUT_n.n12 vco_varactors_0/OUT_n.n4 2.24507
R354 vco_varactors_0/OUT_n.n34 vco_varactors_0/OUT_n.n15 2.24507
R355 vco_varactors_0/OUT_n.n39 vco_varactors_0/OUT_n.n38 2.24507
R356 vco_varactors_0/OUT_n.n50 vco_varactors_0/OUT_n.n0 2.24507
R357 vco_varactors_0/OUT_n.n41 vco_varactors_0/OUT_n.n3 2.24507
R358 vco_varactors_0/OUT_n.n5 vco_varactors_0/OUT_n.t4 2.47914
R359 vco_varactors_0/OUT_n.n6 vco_varactors_0/OUT_n.t7 2.47914
R360 vco_varactors_0/OUT_n.n7 vco_varactors_0/OUT_n.t10 2.47914
R361 vco_varactors_0/OUT_n.n8 vco_varactors_0/OUT_n.t13 2.47914
R362 vco_varactors_0/OUT_n.n9 vco_varactors_0/OUT_n.t16 2.47914
R363 vco_varactors_0/OUT_n.n10 vco_varactors_0/OUT_n.t19 2.47914
R364 vco_varactors_0/OUT_n.n43 vco_varactors_0/OUT_n.t3 2.47914
R365 vco_varactors_0/OUT_n.n44 vco_varactors_0/OUT_n.t6 2.47914
R366 vco_varactors_0/OUT_n.n45 vco_varactors_0/OUT_n.t9 2.47914
R367 vco_varactors_0/OUT_n.n46 vco_varactors_0/OUT_n.t12 2.47914
R368 vco_varactors_0/OUT_n.n47 vco_varactors_0/OUT_n.t15 2.47914
R369 vco_varactors_0/OUT_n.n48 vco_varactors_0/OUT_n.t18 2.47914
R370 vco_varactors_0/OUT_n.n21 vco_varactors_0/OUT_n.t5 2.47914
R371 vco_varactors_0/OUT_n.n22 vco_varactors_0/OUT_n.t8 2.47914
R372 vco_varactors_0/OUT_n.n23 vco_varactors_0/OUT_n.t11 2.47914
R373 vco_varactors_0/OUT_n.n24 vco_varactors_0/OUT_n.t14 2.47914
R374 vco_varactors_0/OUT_n.n25 vco_varactors_0/OUT_n.t17 2.47914
R375 vco_varactors_0/OUT_n.n26 vco_varactors_0/OUT_n.t20 2.47914
R376 vco_varactors_0/OUT_n.n28 vco_varactors_0/OUT_n.n19 1.14883
R377 vco_varactors_0/OUT_n.n19 vco_varactors_0/OUT_n.n18 1.14864
R378 vco_varactors_0/OUT_n.n6 vco_varactors_0/OUT_n.n5 0.564047
R379 vco_varactors_0/OUT_n.n7 vco_varactors_0/OUT_n.n6 0.564047
R380 vco_varactors_0/OUT_n.n8 vco_varactors_0/OUT_n.n7 0.564047
R381 vco_varactors_0/OUT_n.n9 vco_varactors_0/OUT_n.n8 0.564047
R382 vco_varactors_0/OUT_n.n10 vco_varactors_0/OUT_n.n9 0.564047
R383 vco_varactors_0/OUT_n.n44 vco_varactors_0/OUT_n.n43 0.564047
R384 vco_varactors_0/OUT_n.n45 vco_varactors_0/OUT_n.n44 0.564047
R385 vco_varactors_0/OUT_n.n46 vco_varactors_0/OUT_n.n45 0.564047
R386 vco_varactors_0/OUT_n.n47 vco_varactors_0/OUT_n.n46 0.564047
R387 vco_varactors_0/OUT_n.n48 vco_varactors_0/OUT_n.n47 0.564047
R388 vco_varactors_0/OUT_n.n22 vco_varactors_0/OUT_n.n21 0.564047
R389 vco_varactors_0/OUT_n.n23 vco_varactors_0/OUT_n.n22 0.564047
R390 vco_varactors_0/OUT_n.n24 vco_varactors_0/OUT_n.n23 0.564047
R391 vco_varactors_0/OUT_n.n25 vco_varactors_0/OUT_n.n24 0.564047
R392 vco_varactors_0/OUT_n.n26 vco_varactors_0/OUT_n.n25 0.564047
R393 vco_varactors_0/OUT_n.n11 vco_varactors_0/OUT_n.n10 0.266749
R394 vco_varactors_0/OUT_n.n49 vco_varactors_0/OUT_n.n48 0.266749
R395 vco_varactors_0/OUT_n.n27 vco_varactors_0/OUT_n.n26 0.266749
R396 vco_varactors_0/OUT_n.n36 vco_varactors_0/OUT_n.n32 0.222125
R397 vco_varactors_0/OUT_n.n52 vco_varactors_0/OUT_n.n39 0.222125
R398 vco_varactors_0/OUT_n.n55 vco_varactors_0/OUT_n.n1 0.0999737
R399 vco_varactors_0/OUT_n.n39 vco_varactors_0/OUT_n.n4 0.024125
R400 OUT_n vco_varactors_0/OUT_n.n0 0.0190625
R401 vco_varactors_0/OUT_n.n28 vco_varactors_0/OUT_n.n27 0.0135504
R402 vco_varactors_0/OUT_n.n54 vco_varactors_0/OUT_n.n2 0.0131126
R403 vco_varactors_0/OUT_n.n29 vco_varactors_0/OUT_n.n28 0.0130967
R404 vco_varactors_0/OUT_n.n31 vco_varactors_0/OUT_n.n18 0.0129243
R405 vco_varactors_0/OUT_n.n13 vco_varactors_0/OUT_n.n12 0.0128555
R406 vco_varactors_0/OUT_n.n37 vco_varactors_0/OUT_n.n15 0.0128555
R407 vco_varactors_0/OUT_n.n38 vco_varactors_0/OUT_n.n14 0.0128555
R408 vco_varactors_0/OUT_n.n51 vco_varactors_0/OUT_n.n50 0.0128555
R409 vco_varactors_0/OUT_n.n53 vco_varactors_0/OUT_n.n3 0.0128555
R410 vco_varactors_0/OUT_n.n20 vco_varactors_0/OUT_n.n16 0.0128555
R411 vco_varactors_0/OUT_n.n29 vco_varactors_0/OUT_n.n16 0.0128555
R412 vco_varactors_0/OUT_n.n12 vco_varactors_0/OUT_n.n11 0.0128555
R413 vco_varactors_0/OUT_n.n15 vco_varactors_0/OUT_n.n13 0.0128555
R414 vco_varactors_0/OUT_n.n38 vco_varactors_0/OUT_n.n37 0.0128555
R415 vco_varactors_0/OUT_n.n50 vco_varactors_0/OUT_n.n49 0.0128555
R416 vco_varactors_0/OUT_n.n51 vco_varactors_0/OUT_n.n3 0.0128555
R417 vco_varactors_0/OUT_n.n30 vco_varactors_0/OUT_n.n17 0.0127816
R418 vco_varactors_0/OUT_n.n36 vco_varactors_0/OUT_n.n35 0.0127816
R419 vco_varactors_0/OUT_n.n33 vco_varactors_0/OUT_n.n4 0.0127816
R420 vco_varactors_0/OUT_n.n52 vco_varactors_0/OUT_n.n42 0.0127816
R421 vco_varactors_0/OUT_n.n40 vco_varactors_0/OUT_n.n0 0.0127816
R422 vco_varactors_0/OUT_n.n32 vco_varactors_0/OUT_n.n17 0.0127816
R423 vco_varactors_0/OUT_n.n35 vco_varactors_0/OUT_n.n34 0.0127816
R424 vco_varactors_0/OUT_n.n34 vco_varactors_0/OUT_n.n33 0.0127816
R425 vco_varactors_0/OUT_n.n42 vco_varactors_0/OUT_n.n41 0.0127816
R426 vco_varactors_0/OUT_n.n41 vco_varactors_0/OUT_n.n40 0.0127816
R427 vco_varactors_0/OUT_n.n20 vco_varactors_0/OUT_n.n18 0.0127254
R428 vco_varactors_0/OUT_n.n54 vco_varactors_0/OUT_n.n53 0.0125997
R429 OUT_n vco_varactors_0/OUT_n.n55 0.003875
R430 vco_varactors_0/OUT_n.n30 vco_varactors_0/OUT_n.n19 0.0010625
R431 vco_core_0/ISS.n11 vco_core_0/ISS.t18 7.21579
R432 vco_core_0/ISS.n1 vco_core_0/ISS.t0 7.21579
R433 vco_core_0/ISS.n9 vco_core_0/ISS.t16 6.7015
R434 vco_core_0/ISS.n8 vco_core_0/ISS.t12 6.7015
R435 vco_core_0/ISS.n11 vco_core_0/ISS.n10 6.292
R436 vco_core_0/ISS.n13 vco_core_0/ISS.n12 6.292
R437 vco_core_0/ISS.n15 vco_core_0/ISS.n14 6.292
R438 vco_core_0/ISS.n17 vco_core_0/ISS.n16 6.292
R439 vco_core_0/ISS.n7 vco_core_0/ISS.n6 6.292
R440 vco_core_0/ISS.n5 vco_core_0/ISS.n4 6.292
R441 vco_core_0/ISS.n3 vco_core_0/ISS.n2 6.292
R442 vco_core_0/ISS.n1 vco_core_0/ISS.n0 6.292
R443 vco_core_0/ISS.n9 vco_core_0/ISS.n8 2.2505
R444 vco_core_0/ISS.n3 vco_core_0/ISS.n1 0.514786
R445 vco_core_0/ISS.n5 vco_core_0/ISS.n3 0.514786
R446 vco_core_0/ISS.n7 vco_core_0/ISS.n5 0.514786
R447 vco_core_0/ISS.n8 vco_core_0/ISS.n7 0.514786
R448 vco_core_0/ISS.n17 vco_core_0/ISS.n15 0.514786
R449 vco_core_0/ISS.n15 vco_core_0/ISS.n13 0.514786
R450 vco_core_0/ISS.n13 vco_core_0/ISS.n11 0.514786
R451 vco_core_0/ISS.n10 vco_core_0/ISS.t13 0.41
R452 vco_core_0/ISS.n10 vco_core_0/ISS.t1 0.41
R453 vco_core_0/ISS.n12 vco_core_0/ISS.t10 0.41
R454 vco_core_0/ISS.n12 vco_core_0/ISS.t2 0.41
R455 vco_core_0/ISS.n14 vco_core_0/ISS.t5 0.41
R456 vco_core_0/ISS.n14 vco_core_0/ISS.t6 0.41
R457 vco_core_0/ISS.n16 vco_core_0/ISS.t17 0.41
R458 vco_core_0/ISS.n16 vco_core_0/ISS.t11 0.41
R459 vco_core_0/ISS.n6 vco_core_0/ISS.t4 0.41
R460 vco_core_0/ISS.n6 vco_core_0/ISS.t19 0.41
R461 vco_core_0/ISS.n4 vco_core_0/ISS.t8 0.41
R462 vco_core_0/ISS.n4 vco_core_0/ISS.t3 0.41
R463 vco_core_0/ISS.n2 vco_core_0/ISS.t7 0.41
R464 vco_core_0/ISS.n2 vco_core_0/ISS.t9 0.41
R465 vco_core_0/ISS.n0 vco_core_0/ISS.t14 0.41
R466 vco_core_0/ISS.n0 vco_core_0/ISS.t15 0.41
R467 ISS vco_core_0/ISS.n17 0.321929
R468 ISS vco_core_0/ISS.n9 0.193357
R469 vco_core_0/OUT_p.n33 vco_core_0/OUT_p.t25 208.757
R470 vco_core_0/OUT_p.n33 vco_core_0/OUT_p.t26 182.5
R471 vco_core_0/OUT_p.n34 vco_core_0/OUT_p.t27 182.5
R472 vco_core_0/OUT_p.n35 vco_core_0/OUT_p.t28 182.5
R473 vco_core_0/OUT_p.n36 vco_core_0/OUT_p.t29 182.5
R474 vco_core_0/OUT_p.n37 vco_core_0/OUT_p.t15 92.6015
R475 vco_core_0/OUT_p.n37 vco_core_0/OUT_p.t16 75.3469
R476 vco_core_0/OUT_p.n38 vco_core_0/OUT_p.t17 75.3469
R477 vco_core_0/OUT_p.n39 vco_core_0/OUT_p.t18 75.3469
R478 vco_core_0/OUT_p.n40 vco_core_0/OUT_p.t19 75.3469
R479 vco_core_0/OUT_p.n41 vco_core_0/OUT_p.t20 75.3469
R480 vco_core_0/OUT_p.n42 vco_core_0/OUT_p.t21 75.3469
R481 vco_core_0/OUT_p.n43 vco_core_0/OUT_p.t22 75.3469
R482 vco_core_0/OUT_p.n44 vco_core_0/OUT_p.t23 75.3469
R483 vco_core_0/OUT_p.n45 vco_core_0/OUT_p.t24 75.3469
R484 vco_core_0/OUT_p.n46 vco_core_0/OUT_p.n36 54.4163
R485 vco_core_0/OUT_p.n46 vco_core_0/OUT_p.n45 49.5786
R486 vco_core_0/OUT_p.n34 vco_core_0/OUT_p.n33 23.2668
R487 vco_core_0/OUT_p.n35 vco_core_0/OUT_p.n34 23.2668
R488 vco_core_0/OUT_p.n36 vco_core_0/OUT_p.n35 23.2668
R489 vco_core_0/OUT_p.n38 vco_core_0/OUT_p.n37 17.255
R490 vco_core_0/OUT_p.n39 vco_core_0/OUT_p.n38 17.255
R491 vco_core_0/OUT_p.n40 vco_core_0/OUT_p.n39 17.255
R492 vco_core_0/OUT_p.n41 vco_core_0/OUT_p.n40 17.255
R493 vco_core_0/OUT_p.n42 vco_core_0/OUT_p.n41 17.255
R494 vco_core_0/OUT_p.n43 vco_core_0/OUT_p.n42 17.255
R495 vco_core_0/OUT_p.n44 vco_core_0/OUT_p.n43 17.255
R496 vco_core_0/OUT_p.n45 vco_core_0/OUT_p.n44 17.255
R497 vco_core_0/OUT_p.n3 vco_core_0/OUT_p.t0 7.33033
R498 vco_core_0/OUT_p.n5 vco_core_0/OUT_p.n4 7.14008
R499 vco_core_0/OUT_p.n3 vco_core_0/OUT_p.n2 7.14008
R500 vco_core_0/OUT_p.n32 vco_core_0/OUT_p.n14 4.5005
R501 vco_core_0/OUT_p.n32 vco_core_0/OUT_p.n15 4.5005
R502 vco_core_0/OUT_p.n32 vco_core_0/OUT_p.n31 4.5005
R503 vco_core_0/OUT_p.n31 vco_core_0/OUT_p.n30 4.5005
R504 vco_core_0/OUT_p.n7 vco_core_0/OUT_p.n6 4.5005
R505 vco_core_0/OUT_p.n11 vco_core_0/OUT_p.n6 4.5005
R506 vco_core_0/OUT_p.n12 vco_core_0/OUT_p.n11 4.5005
R507 vco_core_0/OUT_p.n18 vco_core_0/OUT_p.n16 4.04562
R508 vco_core_0/OUT_p.n24 vco_core_0/OUT_p.n23 3.92949
R509 vco_core_0/OUT_p.n22 vco_core_0/OUT_p.n21 3.92949
R510 vco_core_0/OUT_p.n20 vco_core_0/OUT_p.n19 3.92949
R511 vco_core_0/OUT_p.n18 vco_core_0/OUT_p.n17 3.92949
R512 vco_core_0/OUT_p.n28 vco_core_0/OUT_p.n14 2.30865
R513 vco_core_0/OUT_p.n28 vco_core_0/OUT_p.n15 2.2505
R514 vco_core_0/OUT_p.n25 vco_core_0/OUT_p.n13 2.24511
R515 vco_core_0/OUT_p.n12 vco_core_0/OUT_p.n1 2.24511
R516 vco_core_0/OUT_p.n10 vco_core_0/OUT_p.n0 2.24511
R517 vco_core_0/OUT_p.n30 vco_core_0/OUT_p.n27 2.24503
R518 vco_core_0/OUT_p.n8 vco_core_0/OUT_p.n1 1.28915
R519 vco_core_0/OUT_p.n29 vco_core_0/OUT_p.n26 1.16348
R520 vco_core_0/OUT_p.n47 vco_core_0/OUT_p.n46 0.7505
R521 OUT_p vco_core_0/OUT_p.n12 0.418812
R522 vco_core_0/OUT_p.n23 vco_core_0/OUT_p.t1 0.41
R523 vco_core_0/OUT_p.n23 vco_core_0/OUT_p.t14 0.41
R524 vco_core_0/OUT_p.n21 vco_core_0/OUT_p.t2 0.41
R525 vco_core_0/OUT_p.n21 vco_core_0/OUT_p.t10 0.41
R526 vco_core_0/OUT_p.n19 vco_core_0/OUT_p.t4 0.41
R527 vco_core_0/OUT_p.n19 vco_core_0/OUT_p.t6 0.41
R528 vco_core_0/OUT_p.n17 vco_core_0/OUT_p.t8 0.41
R529 vco_core_0/OUT_p.n17 vco_core_0/OUT_p.t3 0.41
R530 vco_core_0/OUT_p.n16 vco_core_0/OUT_p.t12 0.41
R531 vco_core_0/OUT_p.n16 vco_core_0/OUT_p.t13 0.41
R532 vco_core_0/OUT_p.n31 vco_core_0/OUT_p.n24 0.40178
R533 vco_core_0/OUT_p.n8 vco_core_0/OUT_p.n6 0.378592
R534 vco_core_0/OUT_p.n11 vco_core_0/OUT_p.n5 0.316949
R535 vco_core_0/OUT_p.n9 vco_core_0/OUT_p.n8 0.198819
R536 OUT_p vco_core_0/OUT_p.n47 0.14825
R537 vco_core_0/OUT_p.n4 vco_core_0/OUT_p.t7 0.1305
R538 vco_core_0/OUT_p.n4 vco_core_0/OUT_p.t9 0.1305
R539 vco_core_0/OUT_p.n2 vco_core_0/OUT_p.t5 0.1305
R540 vco_core_0/OUT_p.n2 vco_core_0/OUT_p.t11 0.1305
R541 vco_core_0/OUT_p.n20 vco_core_0/OUT_p.n18 0.116629
R542 vco_core_0/OUT_p.n22 vco_core_0/OUT_p.n20 0.116629
R543 vco_core_0/OUT_p.n24 vco_core_0/OUT_p.n22 0.116629
R544 vco_core_0/OUT_p.n47 vco_core_0/OUT_p.n32 0.0798125
R545 vco_core_0/OUT_p.n5 vco_core_0/OUT_p.n3 0.060751
R546 vco_core_0/OUT_p.n29 vco_core_0/OUT_p.n28 0.0295769
R547 vco_core_0/OUT_p.n25 vco_core_0/OUT_p.n15 0.0244241
R548 vco_core_0/OUT_p.n11 vco_core_0/OUT_p.n10 0.024125
R549 vco_core_0/OUT_p.n30 vco_core_0/OUT_p.n29 0.0201875
R550 vco_core_0/OUT_p.n9 vco_core_0/OUT_p.n7 0.01325
R551 vco_core_0/OUT_p.n31 vco_core_0/OUT_p.n26 0.0130514
R552 vco_core_0/OUT_p.n27 vco_core_0/OUT_p.n14 0.0129303
R553 vco_core_0/OUT_p.n27 vco_core_0/OUT_p.n15 0.0129303
R554 vco_core_0/OUT_p.n30 vco_core_0/OUT_p.n13 0.0127816
R555 vco_core_0/OUT_p.n32 vco_core_0/OUT_p.n13 0.0127816
R556 vco_core_0/OUT_p.n12 vco_core_0/OUT_p.n0 0.0127816
R557 vco_core_0/OUT_p.n6 vco_core_0/OUT_p.n0 0.0127816
R558 vco_core_0/OUT_p.n7 vco_core_0/OUT_p.n1 0.0127816
R559 vco_core_0/OUT_p.n26 vco_core_0/OUT_p.n25 0.0127478
R560 vco_core_0/OUT_p.n10 vco_core_0/OUT_p.n9 0.011375
R561 vco_core_0/OUT_n.n44 vco_core_0/OUT_n.t25 208.757
R562 vco_core_0/OUT_n.n44 vco_core_0/OUT_n.t26 182.5
R563 vco_core_0/OUT_n.n45 vco_core_0/OUT_n.t27 182.5
R564 vco_core_0/OUT_n.n46 vco_core_0/OUT_n.t28 182.5
R565 vco_core_0/OUT_n.n47 vco_core_0/OUT_n.t29 182.5
R566 vco_core_0/OUT_n.n48 vco_core_0/OUT_n.t15 92.6015
R567 vco_core_0/OUT_n.n48 vco_core_0/OUT_n.t16 75.3469
R568 vco_core_0/OUT_n.n49 vco_core_0/OUT_n.t17 75.3469
R569 vco_core_0/OUT_n.n50 vco_core_0/OUT_n.t18 75.3469
R570 vco_core_0/OUT_n.n51 vco_core_0/OUT_n.t19 75.3469
R571 vco_core_0/OUT_n.n52 vco_core_0/OUT_n.t20 75.3469
R572 vco_core_0/OUT_n.n53 vco_core_0/OUT_n.t21 75.3469
R573 vco_core_0/OUT_n.n54 vco_core_0/OUT_n.t22 75.3469
R574 vco_core_0/OUT_n.n55 vco_core_0/OUT_n.t23 75.3469
R575 vco_core_0/OUT_n.n56 vco_core_0/OUT_n.t24 75.3469
R576 vco_core_0/OUT_n.n57 vco_core_0/OUT_n.n47 58.7858
R577 vco_core_0/OUT_n.n57 vco_core_0/OUT_n.n56 54.2091
R578 vco_core_0/OUT_n.n45 vco_core_0/OUT_n.n44 23.2668
R579 vco_core_0/OUT_n.n46 vco_core_0/OUT_n.n45 23.2668
R580 vco_core_0/OUT_n.n47 vco_core_0/OUT_n.n46 23.2668
R581 vco_core_0/OUT_n.n49 vco_core_0/OUT_n.n48 17.255
R582 vco_core_0/OUT_n.n50 vco_core_0/OUT_n.n49 17.255
R583 vco_core_0/OUT_n.n51 vco_core_0/OUT_n.n50 17.255
R584 vco_core_0/OUT_n.n52 vco_core_0/OUT_n.n51 17.255
R585 vco_core_0/OUT_n.n53 vco_core_0/OUT_n.n52 17.255
R586 vco_core_0/OUT_n.n54 vco_core_0/OUT_n.n53 17.255
R587 vco_core_0/OUT_n.n55 vco_core_0/OUT_n.n54 17.255
R588 vco_core_0/OUT_n.n56 vco_core_0/OUT_n.n55 17.255
R589 vco_core_0/OUT_n.n8 vco_core_0/OUT_n.t4 7.27008
R590 vco_core_0/OUT_n.n7 vco_core_0/OUT_n.n5 7.20033
R591 vco_core_0/OUT_n.n7 vco_core_0/OUT_n.n6 7.14008
R592 vco_core_0/OUT_n.n42 vco_core_0/OUT_n.n26 4.5005
R593 vco_core_0/OUT_n.n43 vco_core_0/OUT_n.n23 4.5005
R594 vco_core_0/OUT_n.n43 vco_core_0/OUT_n.n21 4.5005
R595 vco_core_0/OUT_n.n43 vco_core_0/OUT_n.n42 4.5005
R596 vco_core_0/OUT_n.n16 vco_core_0/OUT_n.n1 4.5005
R597 vco_core_0/OUT_n.n20 vco_core_0/OUT_n.n2 4.5005
R598 vco_core_0/OUT_n.n20 vco_core_0/OUT_n.n19 4.5005
R599 vco_core_0/OUT_n.n20 vco_core_0/OUT_n.n1 4.5005
R600 vco_core_0/OUT_n.n34 vco_core_0/OUT_n.n32 4.04562
R601 vco_core_0/OUT_n.n34 vco_core_0/OUT_n.n33 3.92949
R602 vco_core_0/OUT_n.n36 vco_core_0/OUT_n.n35 3.92949
R603 vco_core_0/OUT_n.n38 vco_core_0/OUT_n.n37 3.92949
R604 vco_core_0/OUT_n.n40 vco_core_0/OUT_n.n39 3.92949
R605 vco_core_0/OUT_n.n18 vco_core_0/OUT_n.n1 2.30865
R606 vco_core_0/OUT_n.n15 vco_core_0/OUT_n.n14 2.30865
R607 vco_core_0/OUT_n.n29 vco_core_0/OUT_n.n28 2.30865
R608 vco_core_0/OUT_n.n14 vco_core_0/OUT_n.n11 2.27412
R609 vco_core_0/OUT_n.n9 vco_core_0/OUT_n.n1 2.2505
R610 vco_core_0/OUT_n.n19 vco_core_0/OUT_n.n10 2.2505
R611 vco_core_0/OUT_n.n11 vco_core_0/OUT_n.n2 2.2505
R612 vco_core_0/OUT_n.n15 vco_core_0/OUT_n.n2 2.2505
R613 vco_core_0/OUT_n.n19 vco_core_0/OUT_n.n18 2.2505
R614 vco_core_0/OUT_n.n28 vco_core_0/OUT_n.n23 2.2505
R615 vco_core_0/OUT_n.n29 vco_core_0/OUT_n.n22 2.24511
R616 vco_core_0/OUT_n.n14 vco_core_0/OUT_n.n0 2.24511
R617 vco_core_0/OUT_n.n26 vco_core_0/OUT_n.n25 2.24503
R618 vco_core_0/OUT_n.n16 vco_core_0/OUT_n.n3 2.24503
R619 vco_core_0/OUT_n.n27 vco_core_0/OUT_n.n24 1.16348
R620 vco_core_0/OUT_n.n13 vco_core_0/OUT_n.n12 1.16058
R621 vco_core_0/OUT_n.n12 vco_core_0/OUT_n.n4 1.16058
R622 vco_core_0/OUT_n.n42 vco_core_0/OUT_n.n41 1.1255
R623 vco_core_0/OUT_n.n31 vco_core_0/OUT_n.n21 1.1255
R624 vco_core_0/OUT_n.n58 vco_core_0/OUT_n.n57 0.78875
R625 vco_core_0/OUT_n.n31 vco_core_0/OUT_n.n30 0.587424
R626 OUT_n vco_core_0/OUT_n.n20 0.418812
R627 vco_core_0/OUT_n.n32 vco_core_0/OUT_n.t6 0.41
R628 vco_core_0/OUT_n.n32 vco_core_0/OUT_n.t5 0.41
R629 vco_core_0/OUT_n.n33 vco_core_0/OUT_n.t8 0.41
R630 vco_core_0/OUT_n.n33 vco_core_0/OUT_n.t7 0.41
R631 vco_core_0/OUT_n.n35 vco_core_0/OUT_n.t10 0.41
R632 vco_core_0/OUT_n.n35 vco_core_0/OUT_n.t9 0.41
R633 vco_core_0/OUT_n.n37 vco_core_0/OUT_n.t12 0.41
R634 vco_core_0/OUT_n.n37 vco_core_0/OUT_n.t11 0.41
R635 vco_core_0/OUT_n.n39 vco_core_0/OUT_n.t14 0.41
R636 vco_core_0/OUT_n.n39 vco_core_0/OUT_n.t13 0.41
R637 vco_core_0/OUT_n.n41 vco_core_0/OUT_n.n40 0.40178
R638 vco_core_0/OUT_n.n58 vco_core_0/OUT_n.n43 0.210313
R639 vco_core_0/OUT_n.n5 vco_core_0/OUT_n.t1 0.1305
R640 vco_core_0/OUT_n.n5 vco_core_0/OUT_n.t2 0.1305
R641 vco_core_0/OUT_n.n6 vco_core_0/OUT_n.t0 0.1305
R642 vco_core_0/OUT_n.n6 vco_core_0/OUT_n.t3 0.1305
R643 vco_core_0/OUT_n.n40 vco_core_0/OUT_n.n38 0.116629
R644 vco_core_0/OUT_n.n38 vco_core_0/OUT_n.n36 0.116629
R645 vco_core_0/OUT_n.n36 vco_core_0/OUT_n.n34 0.116629
R646 vco_core_0/OUT_n.n9 vco_core_0/OUT_n.n8 0.0966969
R647 vco_core_0/OUT_n.n8 vco_core_0/OUT_n.n7 0.060751
R648 vco_core_0/OUT_n.n17 vco_core_0/OUT_n.n15 0.0295769
R649 vco_core_0/OUT_n.n18 vco_core_0/OUT_n.n17 0.0295769
R650 vco_core_0/OUT_n.n28 vco_core_0/OUT_n.n27 0.0295769
R651 vco_core_0/OUT_n.n41 vco_core_0/OUT_n.n31 0.0244241
R652 vco_core_0/OUT_n.n10 vco_core_0/OUT_n.n9 0.024125
R653 vco_core_0/OUT_n.n27 vco_core_0/OUT_n.n26 0.0201875
R654 vco_core_0/OUT_n.n17 vco_core_0/OUT_n.n16 0.0201875
R655 OUT_n vco_core_0/OUT_n.n58 0.01775
R656 vco_core_0/OUT_n.n42 vco_core_0/OUT_n.n24 0.0130514
R657 vco_core_0/OUT_n.n14 vco_core_0/OUT_n.n13 0.0130413
R658 vco_core_0/OUT_n.n4 vco_core_0/OUT_n.n1 0.0130413
R659 vco_core_0/OUT_n.n30 vco_core_0/OUT_n.n29 0.012962
R660 vco_core_0/OUT_n.n19 vco_core_0/OUT_n.n3 0.0129303
R661 vco_core_0/OUT_n.n25 vco_core_0/OUT_n.n21 0.0129303
R662 vco_core_0/OUT_n.n25 vco_core_0/OUT_n.n23 0.0129303
R663 vco_core_0/OUT_n.n3 vco_core_0/OUT_n.n2 0.0129303
R664 vco_core_0/OUT_n.n43 vco_core_0/OUT_n.n22 0.0127816
R665 vco_core_0/OUT_n.n26 vco_core_0/OUT_n.n22 0.0127816
R666 vco_core_0/OUT_n.n20 vco_core_0/OUT_n.n0 0.0127816
R667 vco_core_0/OUT_n.n16 vco_core_0/OUT_n.n0 0.0127816
R668 vco_core_0/OUT_n.n19 vco_core_0/OUT_n.n4 0.0127577
R669 vco_core_0/OUT_n.n13 vco_core_0/OUT_n.n2 0.0127577
R670 vco_core_0/OUT_n.n24 vco_core_0/OUT_n.n21 0.0127478
R671 vco_core_0/OUT_n.n30 vco_core_0/OUT_n.n23 0.0127129
R672 vco_core_0/OUT_n.n12 vco_core_0/OUT_n.n11 0.0123125
R673 vco_core_0/OUT_n.n12 vco_core_0/OUT_n.n10 0.0123125
R674 vco_core_0/VDD.t6 vco_core_0/VDD.t8 47.4782
R675 vco_core_0/VDD.t4 vco_core_0/VDD.t6 47.4782
R676 vco_core_0/VDD.t2 vco_core_0/VDD.t4 47.4782
R677 vco_core_0/VDD.t0 vco_core_0/VDD.t2 47.4782
R678 vco_core_0/VDD.t16 vco_core_0/VDD.t18 47.4782
R679 vco_core_0/VDD.t14 vco_core_0/VDD.t16 47.4782
R680 vco_core_0/VDD.t12 vco_core_0/VDD.t14 47.4782
R681 vco_core_0/VDD.t10 vco_core_0/VDD.t12 47.4782
R682 vco_core_0/VDD.n5 vco_core_0/VDD.t0 11.212
R683 vco_core_0/VDD.n3 vco_core_0/VDD.t10 11.212
R684 vco_core_0/VDD.n2 vco_core_0/VDD.n0 7.65437
R685 vco_core_0/VDD.n5 vco_core_0/VDD.t1 7.34722
R686 vco_core_0/VDD.n4 vco_core_0/VDD.t11 7.27008
R687 vco_core_0/VDD.n7 vco_core_0/VDD.n6 7.14008
R688 vco_core_0/VDD.n9 vco_core_0/VDD.n8 7.14008
R689 vco_core_0/VDD.n2 vco_core_0/VDD.n1 7.14008
R690 VDD vco_core_0/VDD.n4 2.60407
R691 VDD vco_core_0/VDD.n9 1.18979
R692 vco_core_0/VDD.n9 vco_core_0/VDD.n7 0.514786
R693 vco_core_0/VDD.n3 vco_core_0/VDD.n2 0.334786
R694 vco_core_0/VDD.n7 vco_core_0/VDD.n5 0.334786
R695 vco_core_0/VDD.n6 vco_core_0/VDD.t5 0.1305
R696 vco_core_0/VDD.n6 vco_core_0/VDD.t3 0.1305
R697 vco_core_0/VDD.n8 vco_core_0/VDD.t9 0.1305
R698 vco_core_0/VDD.n8 vco_core_0/VDD.t7 0.1305
R699 vco_core_0/VDD.n1 vco_core_0/VDD.t15 0.1305
R700 vco_core_0/VDD.n1 vco_core_0/VDD.t13 0.1305
R701 vco_core_0/VDD.n0 vco_core_0/VDD.t19 0.1305
R702 vco_core_0/VDD.n0 vco_core_0/VDD.t17 0.1305
R703 vco_core_0/VDD.n4 vco_core_0/VDD.n3 0.0776429
R704 vco_core_0/GND.n1 vco_core_0/GND.t10 862.245
R705 vco_core_0/GND.t9 vco_core_0/GND.n1 862.245
R706 vco_core_0/GND.t19 vco_core_0/GND.n0 323.325
R707 GND vco_core_0/GND.t0 320.079
R708 vco_core_0/GND.t18 vco_core_0/GND.t19 176.871
R709 vco_core_0/GND.t17 vco_core_0/GND.t18 176.871
R710 vco_core_0/GND.t16 vco_core_0/GND.t17 176.871
R711 vco_core_0/GND.t15 vco_core_0/GND.t16 176.871
R712 vco_core_0/GND.t14 vco_core_0/GND.t15 176.871
R713 vco_core_0/GND.t13 vco_core_0/GND.t14 176.871
R714 vco_core_0/GND.t12 vco_core_0/GND.t13 176.871
R715 vco_core_0/GND.t11 vco_core_0/GND.t12 176.871
R716 vco_core_0/GND.t10 vco_core_0/GND.t11 176.871
R717 vco_core_0/GND.t8 vco_core_0/GND.t9 176.871
R718 vco_core_0/GND.t7 vco_core_0/GND.t8 176.871
R719 vco_core_0/GND.t6 vco_core_0/GND.t7 176.871
R720 vco_core_0/GND.t5 vco_core_0/GND.t6 176.871
R721 vco_core_0/GND.t4 vco_core_0/GND.t5 176.871
R722 vco_core_0/GND.t3 vco_core_0/GND.t4 176.871
R723 vco_core_0/GND.t2 vco_core_0/GND.t3 176.871
R724 vco_core_0/GND.t1 vco_core_0/GND.t2 176.871
R725 vco_core_0/GND.t0 vco_core_0/GND.t1 176.871
R726 vco_core_0/GND.n1 vco_core_0/GND.n0 9.78339
R727 GND vco_core_0/GND.n0 3.24693
R728 OUT_n.n55 OUT_n.n54 208.757
R729 OUT_n.n55 OUT_n.n53 182.5
R730 OUT_n.n56 OUT_n.n52 182.5
R731 OUT_n.n57 OUT_n.n51 182.5
R732 OUT_n.n58 OUT_n.n50 182.5
R733 OUT_n.n61 OUT_n.n59 92.6015
R734 OUT_n.n61 OUT_n.n60 75.3469
R735 OUT_n.n63 OUT_n.n62 75.3469
R736 OUT_n.n65 OUT_n.n64 75.3469
R737 OUT_n.n67 OUT_n.n66 75.3469
R738 OUT_n.n69 OUT_n.n68 75.3469
R739 OUT_n.n71 OUT_n.n70 75.3469
R740 OUT_n.n73 OUT_n.n72 75.3469
R741 OUT_n.n75 OUT_n.n74 75.3469
R742 OUT_n.n77 OUT_n.n76 75.3469
R743 OUT_n.n78 OUT_n.n58 58.7858
R744 OUT_n.n78 OUT_n.n77 54.2091
R745 OUT_n.n56 OUT_n.n55 23.2668
R746 OUT_n.n57 OUT_n.n56 23.2668
R747 OUT_n.n58 OUT_n.n57 23.2668
R748 OUT_n.n63 OUT_n.n61 17.255
R749 OUT_n.n65 OUT_n.n63 17.255
R750 OUT_n.n67 OUT_n.n65 17.255
R751 OUT_n.n69 OUT_n.n67 17.255
R752 OUT_n.n71 OUT_n.n69 17.255
R753 OUT_n.n73 OUT_n.n71 17.255
R754 OUT_n.n75 OUT_n.n73 17.255
R755 OUT_n.n77 OUT_n.n75 17.255
R756 OUT_n.n91 OUT_n.n90 12.234
R757 OUT_n.n104 OUT_n.n1 4.69945
R758 OUT_n.n48 OUT_n.n42 4.5005
R759 OUT_n.n49 OUT_n.n39 4.5005
R760 OUT_n.n49 OUT_n.n37 4.5005
R761 OUT_n.n49 OUT_n.n48 4.5005
R762 OUT_n.n32 OUT_n.n22 4.5005
R763 OUT_n.n36 OUT_n.n23 4.5005
R764 OUT_n.n36 OUT_n.n35 4.5005
R765 OUT_n.n36 OUT_n.n22 4.5005
R766 OUT_n.n106 OUT_n.n1 4.5005
R767 OUT_n.n93 OUT_n.n11 4.5005
R768 OUT_n.n93 OUT_n.n12 4.5005
R769 OUT_n.n93 OUT_n.n92 4.5005
R770 OUT_n.n92 OUT_n.n15 4.5005
R771 OUT_n.n100 OUT_n.n5 4.5005
R772 OUT_n.n100 OUT_n.n7 4.5005
R773 OUT_n.n97 OUT_n.n7 4.5005
R774 OUT_n.n98 OUT_n.n4 4.5005
R775 OUT_n.n98 OUT_n.n97 4.5005
R776 OUT_n.n97 OUT_n.n8 4.5005
R777 OUT_n.n107 OUT_n.n106 4.5005
R778 OUT_n.n108 OUT_n.n0 4.5005
R779 OUT_n.n108 OUT_n.n107 4.5005
R780 OUT_n.n107 OUT_n.n2 4.5005
R781 OUT_n.n85 OUT_n.n82 4.5005
R782 OUT_n.n87 OUT_n.n82 4.5005
R783 OUT_n.n89 OUT_n.n82 4.5005
R784 OUT_n.n88 OUT_n.n87 4.5005
R785 OUT_n.n89 OUT_n.n88 4.5005
R786 OUT_n.n87 OUT_n.n81 4.5005
R787 OUT_n.n89 OUT_n.n81 4.5005
R788 OUT_n.n90 OUT_n.n89 4.5005
R789 OUT_n.n110 OUT_n.n109 2.39321
R790 OUT_n.n34 OUT_n.n22 2.30865
R791 OUT_n.n31 OUT_n.n30 2.30865
R792 OUT_n.n48 OUT_n.n47 2.30865
R793 OUT_n.n45 OUT_n.n44 2.30865
R794 OUT_n.n16 OUT_n.n11 2.28868
R795 OUT_n.n30 OUT_n.n27 2.27412
R796 OUT_n.n26 OUT_n.n22 2.27412
R797 OUT_n.n35 OUT_n.n26 2.2505
R798 OUT_n.n27 OUT_n.n23 2.2505
R799 OUT_n.n31 OUT_n.n23 2.2505
R800 OUT_n.n35 OUT_n.n34 2.2505
R801 OUT_n.n45 OUT_n.n39 2.2505
R802 OUT_n.n47 OUT_n.n37 2.2505
R803 OUT_n.n16 OUT_n.n12 2.2505
R804 OUT_n.n18 OUT_n.n13 2.2505
R805 OUT_n.n92 OUT_n.n91 2.2505
R806 OUT_n.n84 OUT_n.n83 2.24834
R807 OUT_n.n83 OUT_n.n19 2.24834
R808 OUT_n.n86 OUT_n.n85 2.24834
R809 OUT_n.n44 OUT_n.n38 2.24511
R810 OUT_n.n30 OUT_n.n21 2.24511
R811 OUT_n.n13 OUT_n.n10 2.24511
R812 OUT_n.n96 OUT_n.n5 2.24511
R813 OUT_n.n94 OUT_n.n8 2.24511
R814 OUT_n.n104 OUT_n.n103 2.24511
R815 OUT_n.n101 OUT_n.n2 2.24511
R816 OUT_n.n15 OUT_n.n14 2.24507
R817 OUT_n.n6 OUT_n.n4 2.24507
R818 OUT_n.n95 OUT_n.n9 2.24507
R819 OUT_n.n100 OUT_n.n99 2.24507
R820 OUT_n.n105 OUT_n.n0 2.24507
R821 OUT_n.n102 OUT_n.n3 2.24507
R822 OUT_n.n42 OUT_n.n41 2.24503
R823 OUT_n.n32 OUT_n.n24 2.24503
R824 OUT_n.n90 OUT_n.n20 2.24502
R825 OUT_n.n89 OUT_n.n80 1.50908
R826 OUT_n.n29 OUT_n.n28 1.16058
R827 OUT_n.n28 OUT_n.n25 1.16058
R828 OUT_n.n43 OUT_n.n40 1.15042
R829 OUT_n.n79 OUT_n.n78 0.78875
R830 OUT_n.n80 OUT_n.n36 0.415062
R831 OUT_n.n97 OUT_n.n93 0.222125
R832 OUT_n.n107 OUT_n.n100 0.222125
R833 OUT_n.n79 OUT_n.n49 0.210313
R834 OUT_n.n110 OUT_n.n1 0.0999737
R835 OUT_n.n82 OUT_n 0.0511
R836 OUT_n.n91 OUT_n.n18 0.0386818
R837 OUT_n.n33 OUT_n.n31 0.0295769
R838 OUT_n.n34 OUT_n.n33 0.0295769
R839 OUT_n.n46 OUT_n.n45 0.0295769
R840 OUT_n.n47 OUT_n.n46 0.0295769
R841 OUT_n.n89 OUT_n.n83 0.0245
R842 OUT_n.n87 OUT_n.n83 0.0245
R843 OUT_n.n13 OUT_n.n12 0.0242736
R844 OUT_n.n92 OUT_n.n13 0.0242736
R845 OUT_n.n100 OUT_n.n4 0.024125
R846 OUT_n.n46 OUT_n.n42 0.0201875
R847 OUT_n.n33 OUT_n.n32 0.0201875
R848 OUT_n.n17 OUT_n.n16 0.0195909
R849 OUT_n.n18 OUT_n.n17 0.0195909
R850 OUT_n OUT_n.n0 0.0190625
R851 OUT_n OUT_n.n79 0.01775
R852 OUT_n.n109 OUT_n.n2 0.0131126
R853 OUT_n.n30 OUT_n.n29 0.0130413
R854 OUT_n.n25 OUT_n.n22 0.0130413
R855 OUT_n.n85 OUT_n.n20 0.0129681
R856 OUT_n.n87 OUT_n.n20 0.0129681
R857 OUT_n.n44 OUT_n.n43 0.012962
R858 OUT_n.n48 OUT_n.n40 0.012962
R859 OUT_n.n35 OUT_n.n24 0.0129303
R860 OUT_n.n41 OUT_n.n37 0.0129303
R861 OUT_n.n41 OUT_n.n39 0.0129303
R862 OUT_n.n24 OUT_n.n23 0.0129303
R863 OUT_n.n7 OUT_n.n6 0.0128555
R864 OUT_n.n98 OUT_n.n9 0.0128555
R865 OUT_n.n99 OUT_n.n8 0.0128555
R866 OUT_n.n14 OUT_n.n12 0.0128555
R867 OUT_n.n106 OUT_n.n105 0.0128555
R868 OUT_n.n108 OUT_n.n3 0.0128555
R869 OUT_n.n14 OUT_n.n11 0.0128555
R870 OUT_n.n6 OUT_n.n5 0.0128555
R871 OUT_n.n9 OUT_n.n7 0.0128555
R872 OUT_n.n99 OUT_n.n98 0.0128555
R873 OUT_n.n105 OUT_n.n104 0.0128555
R874 OUT_n.n106 OUT_n.n3 0.0128555
R875 OUT_n.n49 OUT_n.n38 0.0127816
R876 OUT_n.n42 OUT_n.n38 0.0127816
R877 OUT_n.n36 OUT_n.n21 0.0127816
R878 OUT_n.n32 OUT_n.n21 0.0127816
R879 OUT_n.n93 OUT_n.n10 0.0127816
R880 OUT_n.n97 OUT_n.n96 0.0127816
R881 OUT_n.n94 OUT_n.n4 0.0127816
R882 OUT_n.n107 OUT_n.n103 0.0127816
R883 OUT_n.n101 OUT_n.n0 0.0127816
R884 OUT_n.n15 OUT_n.n10 0.0127816
R885 OUT_n.n96 OUT_n.n95 0.0127816
R886 OUT_n.n95 OUT_n.n94 0.0127816
R887 OUT_n.n103 OUT_n.n102 0.0127816
R888 OUT_n.n102 OUT_n.n101 0.0127816
R889 OUT_n.n35 OUT_n.n25 0.0127577
R890 OUT_n.n29 OUT_n.n23 0.0127577
R891 OUT_n.n40 OUT_n.n37 0.0127129
R892 OUT_n.n43 OUT_n.n39 0.0127129
R893 OUT_n.n109 OUT_n.n108 0.0125997
R894 OUT_n.n28 OUT_n.n27 0.0123125
R895 OUT_n.n28 OUT_n.n26 0.0123125
R896 OUT_n.n88 OUT_n.n84 0.00632702
R897 OUT_n.n90 OUT_n.n19 0.00632702
R898 OUT_n.n84 OUT_n.n82 0.00632702
R899 OUT_n.n81 OUT_n.n19 0.00632702
R900 OUT_n.n86 OUT_n.n81 0.00632702
R901 OUT_n.n88 OUT_n.n86 0.00632702
R902 OUT_n.n80 OUT_n 0.00425
R903 OUT_n OUT_n.n110 0.003875
R904 OUT_n.n17 OUT_n.n15 0.0010625
R905 OUT_p.n30 OUT_p.n29 208.757
R906 OUT_p.n30 OUT_p.n28 182.5
R907 OUT_p.n31 OUT_p.n27 182.5
R908 OUT_p.n32 OUT_p.n26 182.5
R909 OUT_p.n33 OUT_p.n25 182.5
R910 OUT_p.n36 OUT_p.n34 92.6015
R911 OUT_p.n36 OUT_p.n35 75.3469
R912 OUT_p.n38 OUT_p.n37 75.3469
R913 OUT_p.n40 OUT_p.n39 75.3469
R914 OUT_p.n42 OUT_p.n41 75.3469
R915 OUT_p.n44 OUT_p.n43 75.3469
R916 OUT_p.n46 OUT_p.n45 75.3469
R917 OUT_p.n48 OUT_p.n47 75.3469
R918 OUT_p.n50 OUT_p.n49 75.3469
R919 OUT_p.n52 OUT_p.n51 75.3469
R920 OUT_p.n53 OUT_p.n33 54.4163
R921 OUT_p.n53 OUT_p.n52 49.5786
R922 OUT_p.n31 OUT_p.n30 23.2668
R923 OUT_p.n32 OUT_p.n31 23.2668
R924 OUT_p.n33 OUT_p.n32 23.2668
R925 OUT_p.n67 OUT_p.n66 22.7707
R926 OUT_p.n38 OUT_p.n36 17.255
R927 OUT_p.n40 OUT_p.n38 17.255
R928 OUT_p.n42 OUT_p.n40 17.255
R929 OUT_p.n44 OUT_p.n42 17.255
R930 OUT_p.n46 OUT_p.n44 17.255
R931 OUT_p.n48 OUT_p.n46 17.255
R932 OUT_p.n50 OUT_p.n48 17.255
R933 OUT_p.n52 OUT_p.n50 17.255
R934 OUT_p.n98 OUT_p.n68 4.69945
R935 OUT_p.n24 OUT_p.n15 4.5005
R936 OUT_p.n24 OUT_p.n16 4.5005
R937 OUT_p.n24 OUT_p.n23 4.5005
R938 OUT_p.n23 OUT_p.n22 4.5005
R939 OUT_p.n8 OUT_p.n7 4.5005
R940 OUT_p.n12 OUT_p.n7 4.5005
R941 OUT_p.n13 OUT_p.n12 4.5005
R942 OUT_p.n100 OUT_p.n68 4.5005
R943 OUT_p.n85 OUT_p.n84 4.5005
R944 OUT_p.n85 OUT_p.n82 4.5005
R945 OUT_p.n87 OUT_p.n86 4.5005
R946 OUT_p.n86 OUT_p.n85 4.5005
R947 OUT_p.n94 OUT_p.n73 4.5005
R948 OUT_p.n94 OUT_p.n75 4.5005
R949 OUT_p.n91 OUT_p.n75 4.5005
R950 OUT_p.n92 OUT_p.n72 4.5005
R951 OUT_p.n92 OUT_p.n91 4.5005
R952 OUT_p.n91 OUT_p.n76 4.5005
R953 OUT_p.n101 OUT_p.n100 4.5005
R954 OUT_p.n102 OUT_p.n71 4.5005
R955 OUT_p.n102 OUT_p.n101 4.5005
R956 OUT_p.n101 OUT_p.n69 4.5005
R957 OUT_p.n59 OUT_p.n57 4.5005
R958 OUT_p.n62 OUT_p.n57 4.5005
R959 OUT_p.n62 OUT_p.n61 4.5005
R960 OUT_p.n61 OUT_p.n4 4.5005
R961 OUT_p.n58 OUT_p.n4 4.5005
R962 OUT_p.n66 OUT_p.n65 4.5005
R963 OUT_p.n104 OUT_p.n103 2.39321
R964 OUT_p.n20 OUT_p.n15 2.30865
R965 OUT_p.n83 OUT_p.n79 2.25816
R966 OUT_p.n20 OUT_p.n16 2.2505
R967 OUT_p.n65 OUT_p.n3 2.24834
R968 OUT_p.n4 OUT_p.n0 2.24834
R969 OUT_p.n60 OUT_p.n59 2.24834
R970 OUT_p.n17 OUT_p.n14 2.24511
R971 OUT_p.n13 OUT_p.n6 2.24511
R972 OUT_p.n11 OUT_p.n5 2.24511
R973 OUT_p.n90 OUT_p.n73 2.24511
R974 OUT_p.n88 OUT_p.n76 2.24511
R975 OUT_p.n98 OUT_p.n97 2.24511
R976 OUT_p.n95 OUT_p.n69 2.24511
R977 OUT_p.n87 OUT_p.n78 2.24507
R978 OUT_p.n74 OUT_p.n72 2.24507
R979 OUT_p.n89 OUT_p.n77 2.24507
R980 OUT_p.n94 OUT_p.n93 2.24507
R981 OUT_p.n99 OUT_p.n71 2.24507
R982 OUT_p.n96 OUT_p.n70 2.24507
R983 OUT_p.n22 OUT_p.n19 2.24503
R984 OUT_p.n58 OUT_p.n2 2.24502
R985 OUT_p.n66 OUT_p.n1 2.24502
R986 OUT_p.n56 OUT_p.n55 1.52919
R987 OUT_p.n9 OUT_p.n6 1.28915
R988 OUT_p.n21 OUT_p.n18 1.16348
R989 OUT_p.n83 OUT_p.n81 1.14883
R990 OUT_p.n81 OUT_p.n80 1.14864
R991 OUT_p.n63 OUT_p.n62 1.1255
R992 OUT_p.n59 OUT_p.n56 1.1255
R993 OUT_p.n54 OUT_p.n53 0.7505
R994 OUT_p.n64 OUT_p.n63 0.5875
R995 OUT_p.n55 OUT_p.n13 0.415062
R996 OUT_p.n9 OUT_p.n7 0.378592
R997 OUT_p.n91 OUT_p.n87 0.222125
R998 OUT_p.n101 OUT_p.n94 0.222125
R999 OUT_p.n10 OUT_p.n9 0.198819
R1000 OUT_p OUT_p.n54 0.14825
R1001 OUT_p.n104 OUT_p.n68 0.0999737
R1002 OUT_p.n54 OUT_p.n24 0.0798125
R1003 OUT_p.n21 OUT_p.n20 0.0295769
R1004 OUT_p.n63 OUT_p.n56 0.0245
R1005 OUT_p.n17 OUT_p.n16 0.0244241
R1006 OUT_p.n12 OUT_p.n11 0.024125
R1007 OUT_p.n94 OUT_p.n72 0.024125
R1008 OUT_p.n22 OUT_p.n21 0.0201875
R1009 OUT_p.n10 OUT_p.n8 0.01325
R1010 OUT_p.n103 OUT_p.n69 0.0131126
R1011 OUT_p.n84 OUT_p.n83 0.0130967
R1012 OUT_p.n23 OUT_p.n18 0.0130514
R1013 OUT_p.n64 OUT_p.n4 0.013
R1014 OUT_p.n62 OUT_p.n1 0.0129681
R1015 OUT_p.n65 OUT_p.n2 0.0129681
R1016 OUT_p.n62 OUT_p.n2 0.0129681
R1017 OUT_p.n59 OUT_p.n1 0.0129681
R1018 OUT_p.n19 OUT_p.n15 0.0129303
R1019 OUT_p.n19 OUT_p.n16 0.0129303
R1020 OUT_p.n86 OUT_p.n80 0.0129243
R1021 OUT_p.n75 OUT_p.n74 0.0128555
R1022 OUT_p.n92 OUT_p.n77 0.0128555
R1023 OUT_p.n93 OUT_p.n76 0.0128555
R1024 OUT_p.n100 OUT_p.n99 0.0128555
R1025 OUT_p.n102 OUT_p.n70 0.0128555
R1026 OUT_p.n82 OUT_p.n78 0.0128555
R1027 OUT_p.n84 OUT_p.n78 0.0128555
R1028 OUT_p.n74 OUT_p.n73 0.0128555
R1029 OUT_p.n77 OUT_p.n75 0.0128555
R1030 OUT_p.n93 OUT_p.n92 0.0128555
R1031 OUT_p.n99 OUT_p.n98 0.0128555
R1032 OUT_p.n100 OUT_p.n70 0.0128555
R1033 OUT_p.n22 OUT_p.n14 0.0127816
R1034 OUT_p.n24 OUT_p.n14 0.0127816
R1035 OUT_p.n13 OUT_p.n5 0.0127816
R1036 OUT_p.n7 OUT_p.n5 0.0127816
R1037 OUT_p.n8 OUT_p.n6 0.0127816
R1038 OUT_p.n85 OUT_p.n79 0.0127816
R1039 OUT_p.n91 OUT_p.n90 0.0127816
R1040 OUT_p.n88 OUT_p.n72 0.0127816
R1041 OUT_p.n101 OUT_p.n97 0.0127816
R1042 OUT_p.n95 OUT_p.n71 0.0127816
R1043 OUT_p.n87 OUT_p.n79 0.0127816
R1044 OUT_p.n90 OUT_p.n89 0.0127816
R1045 OUT_p.n89 OUT_p.n88 0.0127816
R1046 OUT_p.n97 OUT_p.n96 0.0127816
R1047 OUT_p.n96 OUT_p.n95 0.0127816
R1048 OUT_p.n65 OUT_p.n64 0.0127493
R1049 OUT_p.n18 OUT_p.n17 0.0127478
R1050 OUT_p.n82 OUT_p.n80 0.0127254
R1051 OUT_p.n103 OUT_p.n102 0.0125997
R1052 OUT_p.n11 OUT_p.n10 0.011375
R1053 OUT_p.n71 OUT_p.n67 0.0111875
R1054 OUT_p OUT_p.n67 0.008375
R1055 OUT_p.n57 OUT_p.n3 0.00632702
R1056 OUT_p.n57 OUT_p.n0 0.00632702
R1057 OUT_p.n61 OUT_p.n3 0.00632702
R1058 OUT_p.n66 OUT_p.n0 0.00632702
R1059 OUT_p.n60 OUT_p.n58 0.00632702
R1060 OUT_p.n61 OUT_p.n60 0.00632702
R1061 OUT_p.n58 OUT_p 0.0061
R1062 OUT_p.n55 OUT_p 0.00425
R1063 OUT_p OUT_p.n104 0.003875
R1064 OUT_p.n85 OUT_p.n81 0.0010625
R1065 GND.n75 GND.n25 15825.6
R1066 GND.n27 GND.n26 15825.6
R1067 GND.n65 GND.n33 15825.6
R1068 GND.n35 GND.n34 15825.6
R1069 GND.n55 GND.n40 15825.6
R1070 GND.n42 GND.n41 15825.6
R1071 GND.n98 GND.n7 14843.3
R1072 GND.n95 GND.n9 14843.3
R1073 GND.n92 GND.n10 14843.3
R1074 GND.n89 GND.n14 14843.3
R1075 GND.n86 GND.n15 14843.3
R1076 GND.n83 GND.n19 14843.3
R1077 GND.n21 GND.n19 14843.3
R1078 GND.n86 GND.n17 14843.3
R1079 GND.n30 GND.n14 14843.3
R1080 GND.n92 GND.n12 14843.3
R1081 GND.n37 GND.n9 14843.3
R1082 GND.n98 GND.n6 14843.3
R1083 GND.n29 GND.n25 14843.3
R1084 GND.n28 GND.n27 14843.3
R1085 GND.n33 GND.n32 14843.3
R1086 GND.n36 GND.n35 14843.3
R1087 GND.n50 GND.n6 14843.3
R1088 GND.n22 GND.n21 14843.3
R1089 GND.n29 GND.n22 14843.3
R1090 GND.n70 GND.n17 14843.3
R1091 GND.n70 GND.n28 14843.3
R1092 GND.n31 GND.n30 14843.3
R1093 GND.n32 GND.n31 14843.3
R1094 GND.n60 GND.n12 14843.3
R1095 GND.n60 GND.n36 14843.3
R1096 GND.n38 GND.n37 14843.3
R1097 GND.n39 GND.n38 14843.3
R1098 GND.n50 GND.n49 14843.3
R1099 GND.n49 GND.n42 14843.3
R1100 GND.n40 GND.n39 14843.3
R1101 GND.n77 GND.n76 13968.2
R1102 GND.n46 GND.n45 13348.6
R1103 GND.n82 GND.n20 12907.3
R1104 GND.n76 GND.n75 12361.3
R1105 GND.n74 GND.n26 12358
R1106 GND.n75 GND.n74 12358
R1107 GND.n66 GND.n65 12358
R1108 GND.n66 GND.n26 12358
R1109 GND.n64 GND.n34 12358
R1110 GND.n65 GND.n64 12358
R1111 GND.n54 GND.n41 12358
R1112 GND.n55 GND.n54 12358
R1113 GND.n56 GND.n55 12358
R1114 GND.n56 GND.n34 12358
R1115 GND.n46 GND.n41 12358
R1116 GND.n78 GND.n77 9319.85
R1117 GND.n78 GND.n20 9319.85
R1118 GND.n50 GND.n5 7254.46
R1119 GND.n51 GND.n50 7254.46
R1120 GND.n51 GND.n38 7254.46
R1121 GND.n59 GND.n38 7254.46
R1122 GND.n60 GND.n59 7254.46
R1123 GND.n61 GND.n60 7254.46
R1124 GND.n61 GND.n31 7254.46
R1125 GND.n69 GND.n31 7254.46
R1126 GND.n70 GND.n69 7254.46
R1127 GND.n71 GND.n70 7254.46
R1128 GND.n71 GND.n22 7254.46
R1129 GND.n79 GND.n22 7254.46
R1130 GND.n49 GND.n48 7254.46
R1131 GND.n52 GND.n49 7254.46
R1132 GND.n52 GND.n39 7254.46
R1133 GND.n58 GND.n39 7254.46
R1134 GND.n58 GND.n36 7254.46
R1135 GND.n62 GND.n36 7254.46
R1136 GND.n62 GND.n32 7254.46
R1137 GND.n68 GND.n32 7254.46
R1138 GND.n68 GND.n28 7254.46
R1139 GND.n72 GND.n28 7254.46
R1140 GND.n72 GND.n29 7254.46
R1141 GND.n29 GND.n23 7254.46
R1142 GND.n47 GND.n42 7254.46
R1143 GND.n53 GND.n42 7254.46
R1144 GND.n53 GND.n40 7254.46
R1145 GND.n57 GND.n40 7254.46
R1146 GND.n57 GND.n35 7254.46
R1147 GND.n63 GND.n35 7254.46
R1148 GND.n63 GND.n33 7254.46
R1149 GND.n67 GND.n33 7254.46
R1150 GND.n67 GND.n27 7254.46
R1151 GND.n73 GND.n27 7254.46
R1152 GND.n73 GND.n25 7254.46
R1153 GND.n25 GND.n24 7254.46
R1154 GND.n100 GND.n6 7254.46
R1155 GND.n8 GND.n6 7254.46
R1156 GND.n37 GND.n8 7254.46
R1157 GND.n37 GND.n11 7254.46
R1158 GND.n12 GND.n11 7254.46
R1159 GND.n13 GND.n12 7254.46
R1160 GND.n30 GND.n13 7254.46
R1161 GND.n30 GND.n16 7254.46
R1162 GND.n17 GND.n16 7254.46
R1163 GND.n18 GND.n17 7254.46
R1164 GND.n21 GND.n18 7254.46
R1165 GND.n80 GND.n21 7254.46
R1166 GND.n99 GND.n98 7254.46
R1167 GND.n98 GND.n97 7254.46
R1168 GND.n97 GND.n9 7254.46
R1169 GND.n93 GND.n9 7254.46
R1170 GND.n93 GND.n92 7254.46
R1171 GND.n92 GND.n91 7254.46
R1172 GND.n91 GND.n14 7254.46
R1173 GND.n87 GND.n14 7254.46
R1174 GND.n87 GND.n86 7254.46
R1175 GND.n86 GND.n85 7254.46
R1176 GND.n85 GND.n19 7254.46
R1177 GND.n81 GND.n19 7254.46
R1178 GND.n102 GND.n3 7205.59
R1179 GND.n5 GND.n4 5958.33
R1180 GND.n79 GND.n78 5958.33
R1181 GND.n48 GND.n43 5958.33
R1182 GND.n77 GND.n23 5958.33
R1183 GND.n47 GND.n44 5958.33
R1184 GND.n101 GND.n100 5958.33
R1185 GND.n80 GND.n20 5958.33
R1186 GND.n45 GND.n3 5162.15
R1187 GND.n3 GND.n0 3758.61
R1188 GND.n43 GND.n4 1352
R1189 GND.n102 GND.n101 1340.73
R1190 GND.n104 GND.n1 923.327
R1191 GND.n43 GND.n2 803.4
R1192 GND.n101 GND.n0 600.601
R1193 GND.n83 GND.n82 598.779
R1194 GND.n7 GND.n1 596.577
R1195 GND.n96 GND.n7 596.258
R1196 GND.n96 GND.n95 596.258
R1197 GND.n95 GND.n94 596.258
R1198 GND.n94 GND.n10 596.258
R1199 GND.n90 GND.n10 596.258
R1200 GND.n90 GND.n89 596.258
R1201 GND.n89 GND.n88 596.258
R1202 GND.n88 GND.n15 596.258
R1203 GND.n84 GND.n15 596.258
R1204 GND.n84 GND.n83 596.258
R1205 GND.n44 GND.n2 548.601
R1206 GND.n105 GND.n0 459.312
R1207 GND.n45 GND.n44 286
R1208 GND.n105 GND.n104 29.6996
R1209 GND.n103 GND.n2 13.8013
R1210 GND.n102 GND.n4 11.2672
R1211 GND.n104 GND 10.5548
R1212 GND.n103 GND.n102 9.78339
R1213 GND.n97 GND.n96 4.18571
R1214 GND.n94 GND.n93 4.18571
R1215 GND.n91 GND.n90 4.18571
R1216 GND.n88 GND.n87 4.18571
R1217 GND.n85 GND.n84 4.18571
R1218 GND.n100 GND.n99 4.18571
R1219 GND.n97 GND.n8 4.18571
R1220 GND.n93 GND.n11 4.18571
R1221 GND.n91 GND.n13 4.18571
R1222 GND.n87 GND.n16 4.18571
R1223 GND.n85 GND.n18 4.18571
R1224 GND.n81 GND.n80 4.18571
R1225 GND.n47 GND.n46 4.18571
R1226 GND.n57 GND.n56 4.18571
R1227 GND.n64 GND.n63 4.18571
R1228 GND.n67 GND.n66 4.18571
R1229 GND.n74 GND.n73 4.18571
R1230 GND.n54 GND.n53 4.18571
R1231 GND.n48 GND.n47 4.18571
R1232 GND.n53 GND.n52 4.18571
R1233 GND.n58 GND.n57 4.18571
R1234 GND.n63 GND.n62 4.18571
R1235 GND.n68 GND.n67 4.18571
R1236 GND.n73 GND.n72 4.18571
R1237 GND.n24 GND.n23 4.18571
R1238 GND.n100 GND.n5 4.18571
R1239 GND.n48 GND.n5 4.18571
R1240 GND.n51 GND.n8 4.18571
R1241 GND.n52 GND.n51 4.18571
R1242 GND.n59 GND.n11 4.18571
R1243 GND.n59 GND.n58 4.18571
R1244 GND.n61 GND.n13 4.18571
R1245 GND.n62 GND.n61 4.18571
R1246 GND.n69 GND.n16 4.18571
R1247 GND.n69 GND.n68 4.18571
R1248 GND.n71 GND.n18 4.18571
R1249 GND.n72 GND.n71 4.18571
R1250 GND.n80 GND.n79 4.18571
R1251 GND.n79 GND.n23 4.18571
R1252 GND.n99 GND.n1 3.86584
R1253 GND GND.n103 3.24693
R1254 GND.n106 GND.n105 1.98565
R1255 GND.n82 GND.n81 1.66516
R1256 GND.n76 GND.n24 0.920481
R1257 GND.n106 GND 0.162964
R1258 GND GND.n106 0.140623
C15 GND.n0 vco_inductor_v2_0/VSUBS 0.0019f $ **FLOATING
C16 GND.n1 vco_inductor_v2_0/VSUBS 0 $ **FLOATING
C17 GND.n2 vco_inductor_v2_0/VSUBS 0 $ **FLOATING
C18 GND.n3 vco_inductor_v2_0/VSUBS 0.00722f $ **FLOATING
C19 GND.n4 vco_inductor_v2_0/VSUBS 0 $ **FLOATING
C20 GND.n5 vco_inductor_v2_0/VSUBS 0 $ **FLOATING
C21 GND.n6 vco_inductor_v2_0/VSUBS 0 $ **FLOATING
C22 GND.n7 vco_inductor_v2_0/VSUBS 0 $ **FLOATING
C23 GND.n8 vco_inductor_v2_0/VSUBS 0 $ **FLOATING
C24 GND.n9 vco_inductor_v2_0/VSUBS 0 $ **FLOATING
C25 GND.n10 vco_inductor_v2_0/VSUBS 0 $ **FLOATING
C26 GND.n11 vco_inductor_v2_0/VSUBS 0 $ **FLOATING
C27 GND.n12 vco_inductor_v2_0/VSUBS 0 $ **FLOATING
C28 GND.n13 vco_inductor_v2_0/VSUBS 0 $ **FLOATING
C29 GND.n14 vco_inductor_v2_0/VSUBS 0 $ **FLOATING
C30 GND.n15 vco_inductor_v2_0/VSUBS 0 $ **FLOATING
C31 GND.n16 vco_inductor_v2_0/VSUBS 0 $ **FLOATING
C32 GND.n17 vco_inductor_v2_0/VSUBS 0 $ **FLOATING
C33 GND.n18 vco_inductor_v2_0/VSUBS 0 $ **FLOATING
C34 GND.n19 vco_inductor_v2_0/VSUBS 0 $ **FLOATING
C35 GND.n20 vco_inductor_v2_0/VSUBS 0 $ **FLOATING
C36 GND.n21 vco_inductor_v2_0/VSUBS 0 $ **FLOATING
C37 GND.n22 vco_inductor_v2_0/VSUBS 0 $ **FLOATING
C38 GND.n23 vco_inductor_v2_0/VSUBS 0 $ **FLOATING
C39 GND.n24 vco_inductor_v2_0/VSUBS 0 $ **FLOATING
C40 GND.n25 vco_inductor_v2_0/VSUBS 0 $ **FLOATING
C41 GND.n26 vco_inductor_v2_0/VSUBS 0 $ **FLOATING
C42 GND.n27 vco_inductor_v2_0/VSUBS 0 $ **FLOATING
C43 GND.n28 vco_inductor_v2_0/VSUBS 0 $ **FLOATING
C44 GND.n29 vco_inductor_v2_0/VSUBS 0 $ **FLOATING
C45 GND.n30 vco_inductor_v2_0/VSUBS 0 $ **FLOATING
C46 GND.n31 vco_inductor_v2_0/VSUBS 0 $ **FLOATING
C47 GND.n32 vco_inductor_v2_0/VSUBS 0 $ **FLOATING
C48 GND.n33 vco_inductor_v2_0/VSUBS 0 $ **FLOATING
C49 GND.n34 vco_inductor_v2_0/VSUBS 0 $ **FLOATING
C50 GND.n35 vco_inductor_v2_0/VSUBS 0 $ **FLOATING
C51 GND.n36 vco_inductor_v2_0/VSUBS 0 $ **FLOATING
C52 GND.n37 vco_inductor_v2_0/VSUBS 0 $ **FLOATING
C53 GND.n38 vco_inductor_v2_0/VSUBS 0 $ **FLOATING
C54 GND.n39 vco_inductor_v2_0/VSUBS 0 $ **FLOATING
C55 GND.n40 vco_inductor_v2_0/VSUBS 0 $ **FLOATING
C56 GND.n41 vco_inductor_v2_0/VSUBS 0 $ **FLOATING
C57 GND.n42 vco_inductor_v2_0/VSUBS 0 $ **FLOATING
C58 GND.n43 vco_inductor_v2_0/VSUBS 0 $ **FLOATING
C59 GND.n44 vco_inductor_v2_0/VSUBS 0 $ **FLOATING
C60 GND.n45 vco_inductor_v2_0/VSUBS 0 $ **FLOATING
C61 GND.n46 vco_inductor_v2_0/VSUBS 0 $ **FLOATING
C62 GND.n47 vco_inductor_v2_0/VSUBS 0 $ **FLOATING
C63 GND.n48 vco_inductor_v2_0/VSUBS 0 $ **FLOATING
C64 GND.n49 vco_inductor_v2_0/VSUBS 0 $ **FLOATING
C65 GND.n50 vco_inductor_v2_0/VSUBS 0 $ **FLOATING
C66 GND.n51 vco_inductor_v2_0/VSUBS 0 $ **FLOATING
C67 GND.n52 vco_inductor_v2_0/VSUBS 0 $ **FLOATING
C68 GND.n53 vco_inductor_v2_0/VSUBS 0 $ **FLOATING
C69 GND.n54 vco_inductor_v2_0/VSUBS 0 $ **FLOATING
C70 GND.n55 vco_inductor_v2_0/VSUBS 0 $ **FLOATING
C71 GND.n56 vco_inductor_v2_0/VSUBS 0 $ **FLOATING
C72 GND.n57 vco_inductor_v2_0/VSUBS 0 $ **FLOATING
C73 GND.n58 vco_inductor_v2_0/VSUBS 0 $ **FLOATING
C74 GND.n59 vco_inductor_v2_0/VSUBS 0 $ **FLOATING
C75 GND.n60 vco_inductor_v2_0/VSUBS 0 $ **FLOATING
C76 GND.n61 vco_inductor_v2_0/VSUBS 0 $ **FLOATING
C77 GND.n62 vco_inductor_v2_0/VSUBS 0 $ **FLOATING
C78 GND.n63 vco_inductor_v2_0/VSUBS 0 $ **FLOATING
C79 GND.n64 vco_inductor_v2_0/VSUBS 0 $ **FLOATING
C80 GND.n65 vco_inductor_v2_0/VSUBS 0 $ **FLOATING
C81 GND.n66 vco_inductor_v2_0/VSUBS 0 $ **FLOATING
C82 GND.n67 vco_inductor_v2_0/VSUBS 0 $ **FLOATING
C83 GND.n68 vco_inductor_v2_0/VSUBS 0 $ **FLOATING
C84 GND.n69 vco_inductor_v2_0/VSUBS 0 $ **FLOATING
C85 GND.n70 vco_inductor_v2_0/VSUBS 0 $ **FLOATING
C86 GND.n71 vco_inductor_v2_0/VSUBS 0 $ **FLOATING
C87 GND.n72 vco_inductor_v2_0/VSUBS 0 $ **FLOATING
C88 GND.n73 vco_inductor_v2_0/VSUBS 0 $ **FLOATING
C89 GND.n74 vco_inductor_v2_0/VSUBS 0 $ **FLOATING
C90 GND.n75 vco_inductor_v2_0/VSUBS 0 $ **FLOATING
C91 GND.n76 vco_inductor_v2_0/VSUBS 0 $ **FLOATING
C92 GND.n77 vco_inductor_v2_0/VSUBS 0 $ **FLOATING
C93 GND.n78 vco_inductor_v2_0/VSUBS 0 $ **FLOATING
C94 GND.n79 vco_inductor_v2_0/VSUBS 0 $ **FLOATING
C95 GND.n80 vco_inductor_v2_0/VSUBS 0 $ **FLOATING
C96 GND.n81 vco_inductor_v2_0/VSUBS 0 $ **FLOATING
C97 GND.n82 vco_inductor_v2_0/VSUBS 0 $ **FLOATING
C98 GND.n83 vco_inductor_v2_0/VSUBS 0 $ **FLOATING
C99 GND.n84 vco_inductor_v2_0/VSUBS 0 $ **FLOATING
C100 GND.n85 vco_inductor_v2_0/VSUBS 0 $ **FLOATING
C101 GND.n86 vco_inductor_v2_0/VSUBS 0 $ **FLOATING
C102 GND.n87 vco_inductor_v2_0/VSUBS 0 $ **FLOATING
C103 GND.n88 vco_inductor_v2_0/VSUBS 0 $ **FLOATING
C104 GND.n89 vco_inductor_v2_0/VSUBS 0 $ **FLOATING
C105 GND.n90 vco_inductor_v2_0/VSUBS 0 $ **FLOATING
C106 GND.n91 vco_inductor_v2_0/VSUBS 0 $ **FLOATING
C107 GND.n92 vco_inductor_v2_0/VSUBS 0 $ **FLOATING
C108 GND.n93 vco_inductor_v2_0/VSUBS 0 $ **FLOATING
C109 GND.n94 vco_inductor_v2_0/VSUBS 0 $ **FLOATING
C110 GND.n95 vco_inductor_v2_0/VSUBS 0 $ **FLOATING
C111 GND.n96 vco_inductor_v2_0/VSUBS 0 $ **FLOATING
C112 GND.n97 vco_inductor_v2_0/VSUBS 0 $ **FLOATING
C113 GND.n98 vco_inductor_v2_0/VSUBS 0 $ **FLOATING
C114 GND.n99 vco_inductor_v2_0/VSUBS 0 $ **FLOATING
C115 GND.n100 vco_inductor_v2_0/VSUBS 0 $ **FLOATING
C116 GND.n101 vco_inductor_v2_0/VSUBS 0 $ **FLOATING
C117 GND.n102 vco_inductor_v2_0/VSUBS 0 $ **FLOATING
C118 GND.n103 vco_inductor_v2_0/VSUBS 0 $ **FLOATING
C119 GND.n104 vco_inductor_v2_0/VSUBS 0 $ **FLOATING
C120 GND.n105 vco_inductor_v2_0/VSUBS 0 $ **FLOATING
C121 GND.n106 vco_inductor_v2_0/VSUBS 0 $ **FLOATING
C122 OUT_p.n4 vco_inductor_v2_0/VSUBS 0.00166f $ **FLOATING
C123 OUT_p.n6 vco_inductor_v2_0/VSUBS 0.00154f $ **FLOATING
C124 OUT_p.n7 vco_inductor_v2_0/VSUBS 0.00507f $ **FLOATING
C125 OUT_p.n8 vco_inductor_v2_0/VSUBS 0.00141f $ **FLOATING
C126 OUT_p.n9 vco_inductor_v2_0/VSUBS 0 $ **FLOATING
C127 OUT_p.n10 vco_inductor_v2_0/VSUBS 0.00388f $ **FLOATING
C128 OUT_p.n11 vco_inductor_v2_0/VSUBS 0.00133f $ **FLOATING
C129 OUT_p.n12 vco_inductor_v2_0/VSUBS 0.00526f $ **FLOATING
C130 OUT_p.n13 vco_inductor_v2_0/VSUBS 0.01695f $ **FLOATING
C131 OUT_p.n15 vco_inductor_v2_0/VSUBS 0.00161f $ **FLOATING
C132 OUT_p.n16 vco_inductor_v2_0/VSUBS 0.0018f $ **FLOATING
C133 OUT_p.n17 vco_inductor_v2_0/VSUBS 0.0018f $ **FLOATING
C134 OUT_p.n18 vco_inductor_v2_0/VSUBS 0 $ **FLOATING
C135 OUT_p.n20 vco_inductor_v2_0/VSUBS 0.00119f $ **FLOATING
C136 OUT_p.n21 vco_inductor_v2_0/VSUBS 0.0023f $ **FLOATING
C137 OUT_p.n22 vco_inductor_v2_0/VSUBS 0.00168f $ **FLOATING
C138 OUT_p.n23 vco_inductor_v2_0/VSUBS 0.00794f $ **FLOATING
C139 OUT_p.n24 vco_inductor_v2_0/VSUBS 0.00398f $ **FLOATING
C140 OUT_p.n25 vco_inductor_v2_0/VSUBS 0.00348f $ **FLOATING
C141 OUT_p.n26 vco_inductor_v2_0/VSUBS 0.00348f $ **FLOATING
C142 OUT_p.n27 vco_inductor_v2_0/VSUBS 0.00348f $ **FLOATING
C143 OUT_p.n28 vco_inductor_v2_0/VSUBS 0.00348f $ **FLOATING
C144 OUT_p.n29 vco_inductor_v2_0/VSUBS 0.00365f $ **FLOATING
C145 OUT_p.n30 vco_inductor_v2_0/VSUBS 0.00264f $ **FLOATING
C146 OUT_p.n31 vco_inductor_v2_0/VSUBS 0.00144f $ **FLOATING
C147 OUT_p.n32 vco_inductor_v2_0/VSUBS 0.00144f $ **FLOATING
C148 OUT_p.n33 vco_inductor_v2_0/VSUBS 0.00204f $ **FLOATING
C149 OUT_p.n34 vco_inductor_v2_0/VSUBS 0.0012f $ **FLOATING
C150 OUT_p.n35 vco_inductor_v2_0/VSUBS 0.00109f $ **FLOATING
C151 OUT_p.n36 vco_inductor_v2_0/VSUBS 0.00115f $ **FLOATING
C152 OUT_p.n37 vco_inductor_v2_0/VSUBS 0.00109f $ **FLOATING
C153 OUT_p.n38 vco_inductor_v2_0/VSUBS 0 $ **FLOATING
C154 OUT_p.n39 vco_inductor_v2_0/VSUBS 0.00109f $ **FLOATING
C155 OUT_p.n40 vco_inductor_v2_0/VSUBS 0 $ **FLOATING
C156 OUT_p.n41 vco_inductor_v2_0/VSUBS 0.00109f $ **FLOATING
C157 OUT_p.n42 vco_inductor_v2_0/VSUBS 0 $ **FLOATING
C158 OUT_p.n43 vco_inductor_v2_0/VSUBS 0.00109f $ **FLOATING
C159 OUT_p.n44 vco_inductor_v2_0/VSUBS 0 $ **FLOATING
C160 OUT_p.n45 vco_inductor_v2_0/VSUBS 0.00109f $ **FLOATING
C161 OUT_p.n46 vco_inductor_v2_0/VSUBS 0 $ **FLOATING
C162 OUT_p.n47 vco_inductor_v2_0/VSUBS 0.00109f $ **FLOATING
C163 OUT_p.n48 vco_inductor_v2_0/VSUBS 0 $ **FLOATING
C164 OUT_p.n49 vco_inductor_v2_0/VSUBS 0.00109f $ **FLOATING
C165 OUT_p.n50 vco_inductor_v2_0/VSUBS 0 $ **FLOATING
C166 OUT_p.n51 vco_inductor_v2_0/VSUBS 0.00109f $ **FLOATING
C167 OUT_p.n52 vco_inductor_v2_0/VSUBS 0.0011f $ **FLOATING
C168 OUT_p.n53 vco_inductor_v2_0/VSUBS 0.08909f $ **FLOATING
C169 OUT_p.n54 vco_inductor_v2_0/VSUBS 0.04128f $ **FLOATING
C170 OUT_p.n55 vco_inductor_v2_0/VSUBS 0.06717f $ **FLOATING
C171 OUT_p.n56 vco_inductor_v2_0/VSUBS 0.06128f $ **FLOATING
C172 OUT_p.n57 vco_inductor_v2_0/VSUBS 0.00186f $ **FLOATING
C173 OUT_p.n58 vco_inductor_v2_0/VSUBS 0.0014f $ **FLOATING
C174 OUT_p.n59 vco_inductor_v2_0/VSUBS 0.00162f $ **FLOATING
C175 OUT_p.n61 vco_inductor_v2_0/VSUBS 0.00186f $ **FLOATING
C176 OUT_p.n62 vco_inductor_v2_0/VSUBS 0.00186f $ **FLOATING
C177 OUT_p.n63 vco_inductor_v2_0/VSUBS 0.00516f $ **FLOATING
C178 OUT_p.n64 vco_inductor_v2_0/VSUBS 0 $ **FLOATING
C179 OUT_p.n65 vco_inductor_v2_0/VSUBS 0.00186f $ **FLOATING
C180 OUT_p.n66 vco_inductor_v2_0/VSUBS 0.22088f $ **FLOATING
C181 OUT_p.n67 vco_inductor_v2_0/VSUBS 0.01769f $ **FLOATING
C182 OUT_p.n68 vco_inductor_v2_0/VSUBS 0 $ **FLOATING
C183 OUT_p.n69 vco_inductor_v2_0/VSUBS 0.00161f $ **FLOATING
C184 OUT_p.n71 vco_inductor_v2_0/VSUBS 0.00133f $ **FLOATING
C185 OUT_p.n72 vco_inductor_v2_0/VSUBS 0.00183f $ **FLOATING
C186 OUT_p.n73 vco_inductor_v2_0/VSUBS 0.34325f $ **FLOATING
C187 OUT_p.n75 vco_inductor_v2_0/VSUBS 0.00182f $ **FLOATING
C188 OUT_p.n76 vco_inductor_v2_0/VSUBS 0.0016f $ **FLOATING
C189 OUT_p.n79 vco_inductor_v2_0/VSUBS 0.00198f $ **FLOATING
C190 OUT_p.n80 vco_inductor_v2_0/VSUBS 0 $ **FLOATING
C191 OUT_p.n81 vco_inductor_v2_0/VSUBS 0.00418f $ **FLOATING
C192 OUT_p.n82 vco_inductor_v2_0/VSUBS 0.00182f $ **FLOATING
C193 OUT_p.n83 vco_inductor_v2_0/VSUBS 0.34132f $ **FLOATING
C194 OUT_p.n84 vco_inductor_v2_0/VSUBS 0.00182f $ **FLOATING
C195 OUT_p.n85 vco_inductor_v2_0/VSUBS 0 $ **FLOATING
C196 OUT_p.n86 vco_inductor_v2_0/VSUBS 0.00162f $ **FLOATING
C197 OUT_p.n87 vco_inductor_v2_0/VSUBS 0.00949f $ **FLOATING
C198 OUT_p.n89 vco_inductor_v2_0/VSUBS 0.00183f $ **FLOATING
C199 OUT_p.n91 vco_inductor_v2_0/VSUBS 0.00949f $ **FLOATING
C200 OUT_p.n92 vco_inductor_v2_0/VSUBS 0.00182f $ **FLOATING
C201 OUT_p.n94 vco_inductor_v2_0/VSUBS 0.00949f $ **FLOATING
C202 OUT_p.n96 vco_inductor_v2_0/VSUBS 0.00183f $ **FLOATING
C203 OUT_p.n98 vco_inductor_v2_0/VSUBS 0.34326f $ **FLOATING
C204 OUT_p.n100 vco_inductor_v2_0/VSUBS 0.00182f $ **FLOATING
C205 OUT_p.n101 vco_inductor_v2_0/VSUBS 0.00949f $ **FLOATING
C206 OUT_p.n102 vco_inductor_v2_0/VSUBS 0.00182f $ **FLOATING
C207 OUT_p.n103 vco_inductor_v2_0/VSUBS 0 $ **FLOATING
C208 OUT_p.n104 vco_inductor_v2_0/VSUBS 0 $ **FLOATING
C209 OUT_n.n0 vco_inductor_v2_0/VSUBS 0.00243f $ **FLOATING
C210 OUT_n.n1 vco_inductor_v2_0/VSUBS 0 $ **FLOATING
C211 OUT_n.n2 vco_inductor_v2_0/VSUBS 0.0024f $ **FLOATING
C212 OUT_n.n4 vco_inductor_v2_0/VSUBS 0.00272f $ **FLOATING
C213 OUT_n.n5 vco_inductor_v2_0/VSUBS 0.51147f $ **FLOATING
C214 OUT_n.n7 vco_inductor_v2_0/VSUBS 0.00271f $ **FLOATING
C215 OUT_n.n8 vco_inductor_v2_0/VSUBS 0.00238f $ **FLOATING
C216 OUT_n.n11 vco_inductor_v2_0/VSUBS 0.51149f $ **FLOATING
C217 OUT_n.n12 vco_inductor_v2_0/VSUBS 0.00271f $ **FLOATING
C218 OUT_n.n13 vco_inductor_v2_0/VSUBS 0.00271f $ **FLOATING
C219 OUT_n.n15 vco_inductor_v2_0/VSUBS 0.00139f $ **FLOATING
C220 OUT_n.n16 vco_inductor_v2_0/VSUBS 0.00272f $ **FLOATING
C221 OUT_n.n17 vco_inductor_v2_0/VSUBS 0 $ **FLOATING
C222 OUT_n.n18 vco_inductor_v2_0/VSUBS 0.00126f $ **FLOATING
C223 OUT_n.n22 vco_inductor_v2_0/VSUBS 0.00249f $ **FLOATING
C224 OUT_n.n23 vco_inductor_v2_0/VSUBS 0.00269f $ **FLOATING
C225 OUT_n.n25 vco_inductor_v2_0/VSUBS 0 $ **FLOATING
C226 OUT_n.n26 vco_inductor_v2_0/VSUBS 0.00851f $ **FLOATING
C227 OUT_n.n27 vco_inductor_v2_0/VSUBS 0.00504f $ **FLOATING
C228 OUT_n.n28 vco_inductor_v2_0/VSUBS 0.00568f $ **FLOATING
C229 OUT_n.n29 vco_inductor_v2_0/VSUBS 0 $ **FLOATING
C230 OUT_n.n30 vco_inductor_v2_0/VSUBS 0.00245f $ **FLOATING
C231 OUT_n.n31 vco_inductor_v2_0/VSUBS 0.00178f $ **FLOATING
C232 OUT_n.n32 vco_inductor_v2_0/VSUBS 0.0025f $ **FLOATING
C233 OUT_n.n33 vco_inductor_v2_0/VSUBS 0.00169f $ **FLOATING
C234 OUT_n.n34 vco_inductor_v2_0/VSUBS 0.00178f $ **FLOATING
C235 OUT_n.n35 vco_inductor_v2_0/VSUBS 0.00269f $ **FLOATING
C236 OUT_n.n36 vco_inductor_v2_0/VSUBS 0.02526f $ **FLOATING
C237 OUT_n.n37 vco_inductor_v2_0/VSUBS 0.00269f $ **FLOATING
C238 OUT_n.n39 vco_inductor_v2_0/VSUBS 0.00269f $ **FLOATING
C239 OUT_n.n40 vco_inductor_v2_0/VSUBS 0.00957f $ **FLOATING
C240 OUT_n.n42 vco_inductor_v2_0/VSUBS 0.0025f $ **FLOATING
C241 OUT_n.n43 vco_inductor_v2_0/VSUBS 0.00937f $ **FLOATING
C242 OUT_n.n44 vco_inductor_v2_0/VSUBS 0.00244f $ **FLOATING
C243 OUT_n.n45 vco_inductor_v2_0/VSUBS 0.00178f $ **FLOATING
C244 OUT_n.n46 vco_inductor_v2_0/VSUBS 0.00169f $ **FLOATING
C245 OUT_n.n47 vco_inductor_v2_0/VSUBS 0.00178f $ **FLOATING
C246 OUT_n.n48 vco_inductor_v2_0/VSUBS 0.00264f $ **FLOATING
C247 OUT_n.n49 vco_inductor_v2_0/VSUBS 0.01346f $ **FLOATING
C248 OUT_n.n50 vco_inductor_v2_0/VSUBS 0.00518f $ **FLOATING
C249 OUT_n.n51 vco_inductor_v2_0/VSUBS 0.00518f $ **FLOATING
C250 OUT_n.n52 vco_inductor_v2_0/VSUBS 0.00518f $ **FLOATING
C251 OUT_n.n53 vco_inductor_v2_0/VSUBS 0.00518f $ **FLOATING
C252 OUT_n.n54 vco_inductor_v2_0/VSUBS 0.00544f $ **FLOATING
C253 OUT_n.n55 vco_inductor_v2_0/VSUBS 0.00393f $ **FLOATING
C254 OUT_n.n56 vco_inductor_v2_0/VSUBS 0.00214f $ **FLOATING
C255 OUT_n.n57 vco_inductor_v2_0/VSUBS 0.00214f $ **FLOATING
C256 OUT_n.n58 vco_inductor_v2_0/VSUBS 0.00293f $ **FLOATING
C257 OUT_n.n59 vco_inductor_v2_0/VSUBS 0.00179f $ **FLOATING
C258 OUT_n.n60 vco_inductor_v2_0/VSUBS 0.00163f $ **FLOATING
C259 OUT_n.n61 vco_inductor_v2_0/VSUBS 0.00171f $ **FLOATING
C260 OUT_n.n62 vco_inductor_v2_0/VSUBS 0.00163f $ **FLOATING
C261 OUT_n.n63 vco_inductor_v2_0/VSUBS 0 $ **FLOATING
C262 OUT_n.n64 vco_inductor_v2_0/VSUBS 0.00163f $ **FLOATING
C263 OUT_n.n65 vco_inductor_v2_0/VSUBS 0 $ **FLOATING
C264 OUT_n.n66 vco_inductor_v2_0/VSUBS 0.00163f $ **FLOATING
C265 OUT_n.n67 vco_inductor_v2_0/VSUBS 0 $ **FLOATING
C266 OUT_n.n68 vco_inductor_v2_0/VSUBS 0.00163f $ **FLOATING
C267 OUT_n.n69 vco_inductor_v2_0/VSUBS 0 $ **FLOATING
C268 OUT_n.n70 vco_inductor_v2_0/VSUBS 0.00163f $ **FLOATING
C269 OUT_n.n71 vco_inductor_v2_0/VSUBS 0 $ **FLOATING
C270 OUT_n.n72 vco_inductor_v2_0/VSUBS 0.00163f $ **FLOATING
C271 OUT_n.n73 vco_inductor_v2_0/VSUBS 0 $ **FLOATING
C272 OUT_n.n74 vco_inductor_v2_0/VSUBS 0.00163f $ **FLOATING
C273 OUT_n.n75 vco_inductor_v2_0/VSUBS 0 $ **FLOATING
C274 OUT_n.n76 vco_inductor_v2_0/VSUBS 0.00163f $ **FLOATING
C275 OUT_n.n77 vco_inductor_v2_0/VSUBS 0.00182f $ **FLOATING
C276 OUT_n.n78 vco_inductor_v2_0/VSUBS 0.13552f $ **FLOATING
C277 OUT_n.n79 vco_inductor_v2_0/VSUBS 0.06371f $ **FLOATING
C278 OUT_n.n80 vco_inductor_v2_0/VSUBS 0.06965f $ **FLOATING
C279 OUT_n.n81 vco_inductor_v2_0/VSUBS 0.00277f $ **FLOATING
C280 OUT_n.n82 vco_inductor_v2_0/VSUBS 0.00625f $ **FLOATING
C281 OUT_n.n83 vco_inductor_v2_0/VSUBS 0.00277f $ **FLOATING
C282 OUT_n.n85 vco_inductor_v2_0/VSUBS 0.00242f $ **FLOATING
C283 OUT_n.n87 vco_inductor_v2_0/VSUBS 0.00277f $ **FLOATING
C284 OUT_n.n88 vco_inductor_v2_0/VSUBS 0.00277f $ **FLOATING
C285 OUT_n.n89 vco_inductor_v2_0/VSUBS 0.08312f $ **FLOATING
C286 OUT_n.n90 vco_inductor_v2_0/VSUBS 0.30078f $ **FLOATING
C287 OUT_n.n91 vco_inductor_v2_0/VSUBS 0.02791f $ **FLOATING
C288 OUT_n.n92 vco_inductor_v2_0/VSUBS 0.00238f $ **FLOATING
C289 OUT_n.n93 vco_inductor_v2_0/VSUBS 0.01414f $ **FLOATING
C290 OUT_n.n95 vco_inductor_v2_0/VSUBS 0.00272f $ **FLOATING
C291 OUT_n.n97 vco_inductor_v2_0/VSUBS 0.01414f $ **FLOATING
C292 OUT_n.n98 vco_inductor_v2_0/VSUBS 0.00271f $ **FLOATING
C293 OUT_n.n100 vco_inductor_v2_0/VSUBS 0.01414f $ **FLOATING
C294 OUT_n.n102 vco_inductor_v2_0/VSUBS 0.00272f $ **FLOATING
C295 OUT_n.n104 vco_inductor_v2_0/VSUBS 0.51148f $ **FLOATING
C296 OUT_n.n106 vco_inductor_v2_0/VSUBS 0.00271f $ **FLOATING
C297 OUT_n.n107 vco_inductor_v2_0/VSUBS 0.01414f $ **FLOATING
C298 OUT_n.n108 vco_inductor_v2_0/VSUBS 0.00271f $ **FLOATING
C299 OUT_n.n109 vco_inductor_v2_0/VSUBS 0 $ **FLOATING
C300 OUT_n.n110 vco_inductor_v2_0/VSUBS 0 $ **FLOATING
C301 ISS vco_inductor_v2_0/VSUBS 3.01404f
C302 VDD vco_inductor_v2_0/VSUBS 30.1391f
C303 vco_core_0/VDD.t19 vco_inductor_v2_0/VSUBS 0.1147f $ **FLOATING
C304 vco_core_0/VDD.t17 vco_inductor_v2_0/VSUBS 0.1147f $ **FLOATING
C305 vco_core_0/VDD.n0 vco_inductor_v2_0/VSUBS 0.41072f $ **FLOATING
C306 vco_core_0/VDD.t15 vco_inductor_v2_0/VSUBS 0.1147f $ **FLOATING
C307 vco_core_0/VDD.t13 vco_inductor_v2_0/VSUBS 0.1147f $ **FLOATING
C308 vco_core_0/VDD.n1 vco_inductor_v2_0/VSUBS 0.40685f $ **FLOATING
C309 vco_core_0/VDD.n2 vco_inductor_v2_0/VSUBS 0.10049f $ **FLOATING
C310 vco_core_0/VDD.t18 vco_inductor_v2_0/VSUBS 2.65487f $ **FLOATING
C311 vco_core_0/VDD.t16 vco_inductor_v2_0/VSUBS 0.84956f $ **FLOATING
C312 vco_core_0/VDD.t14 vco_inductor_v2_0/VSUBS 0.84956f $ **FLOATING
C313 vco_core_0/VDD.t12 vco_inductor_v2_0/VSUBS 0.84956f $ **FLOATING
C314 vco_core_0/VDD.t10 vco_inductor_v2_0/VSUBS 2.65207f $ **FLOATING
C315 vco_core_0/VDD.n3 vco_inductor_v2_0/VSUBS 0.05079f $ **FLOATING
C316 vco_core_0/VDD.t11 vco_inductor_v2_0/VSUBS 0.5576f $ **FLOATING
C317 vco_core_0/VDD.n4 vco_inductor_v2_0/VSUBS 0.10507f $ **FLOATING
C318 vco_core_0/VDD.t1 vco_inductor_v2_0/VSUBS 0.55802f $ **FLOATING
C319 vco_core_0/VDD.t8 vco_inductor_v2_0/VSUBS 2.65487f $ **FLOATING
C320 vco_core_0/VDD.t6 vco_inductor_v2_0/VSUBS 0.84956f $ **FLOATING
C321 vco_core_0/VDD.t4 vco_inductor_v2_0/VSUBS 0.84956f $ **FLOATING
C322 vco_core_0/VDD.t2 vco_inductor_v2_0/VSUBS 0.84956f $ **FLOATING
C323 vco_core_0/VDD.t0 vco_inductor_v2_0/VSUBS 2.65207f $ **FLOATING
C324 vco_core_0/VDD.n5 vco_inductor_v2_0/VSUBS 0.08997f $ **FLOATING
C325 vco_core_0/VDD.t5 vco_inductor_v2_0/VSUBS 0.1147f $ **FLOATING
C326 vco_core_0/VDD.t3 vco_inductor_v2_0/VSUBS 0.1147f $ **FLOATING
C327 vco_core_0/VDD.n6 vco_inductor_v2_0/VSUBS 0.40685f $ **FLOATING
C328 vco_core_0/VDD.n7 vco_inductor_v2_0/VSUBS 0.04671f $ **FLOATING
C329 vco_core_0/VDD.t9 vco_inductor_v2_0/VSUBS 0.1147f $ **FLOATING
C330 vco_core_0/VDD.t7 vco_inductor_v2_0/VSUBS 0.1147f $ **FLOATING
C331 vco_core_0/VDD.n8 vco_inductor_v2_0/VSUBS 0.40685f $ **FLOATING
C332 vco_core_0/VDD.n9 vco_inductor_v2_0/VSUBS 0.07018f $ **FLOATING
C333 vco_core_0/OUT_n.n1 vco_inductor_v2_0/VSUBS 0.09955f $ **FLOATING
C334 vco_core_0/OUT_n.n2 vco_inductor_v2_0/VSUBS 0.1107f $ **FLOATING
C335 vco_core_0/OUT_n.n4 vco_inductor_v2_0/VSUBS 0.00184f $ **FLOATING
C336 vco_core_0/OUT_n.t1 vco_inductor_v2_0/VSUBS 0.13494f $ **FLOATING
C337 vco_core_0/OUT_n.t2 vco_inductor_v2_0/VSUBS 0.13494f $ **FLOATING
C338 vco_core_0/OUT_n.n5 vco_inductor_v2_0/VSUBS 0.48019f $ **FLOATING
C339 vco_core_0/OUT_n.t0 vco_inductor_v2_0/VSUBS 0.13494f $ **FLOATING
C340 vco_core_0/OUT_n.t3 vco_inductor_v2_0/VSUBS 0.13494f $ **FLOATING
C341 vco_core_0/OUT_n.n6 vco_inductor_v2_0/VSUBS 0.47863f $ **FLOATING
C342 vco_core_0/OUT_n.n7 vco_inductor_v2_0/VSUBS 0.49568f $ **FLOATING
C343 vco_core_0/OUT_n.t4 vco_inductor_v2_0/VSUBS 0.65599f $ **FLOATING
C344 vco_core_0/OUT_n.n8 vco_inductor_v2_0/VSUBS 0.40695f $ **FLOATING
C345 vco_core_0/OUT_n.n9 vco_inductor_v2_0/VSUBS 0.28429f $ **FLOATING
C346 vco_core_0/OUT_n.n10 vco_inductor_v2_0/VSUBS 0.08408f $ **FLOATING
C347 vco_core_0/OUT_n.n11 vco_inductor_v2_0/VSUBS 0.20735f $ **FLOATING
C348 vco_core_0/OUT_n.n12 vco_inductor_v2_0/VSUBS 0.23398f $ **FLOATING
C349 vco_core_0/OUT_n.n13 vco_inductor_v2_0/VSUBS 0.00184f $ **FLOATING
C350 vco_core_0/OUT_n.n14 vco_inductor_v2_0/VSUBS 0.10084f $ **FLOATING
C351 vco_core_0/OUT_n.n15 vco_inductor_v2_0/VSUBS 0.07327f $ **FLOATING
C352 vco_core_0/OUT_n.n16 vco_inductor_v2_0/VSUBS 0.10276f $ **FLOATING
C353 vco_core_0/OUT_n.n17 vco_inductor_v2_0/VSUBS 0.06948f $ **FLOATING
C354 vco_core_0/OUT_n.n18 vco_inductor_v2_0/VSUBS 0.07327f $ **FLOATING
C355 vco_core_0/OUT_n.n19 vco_inductor_v2_0/VSUBS 0.1107f $ **FLOATING
C356 vco_core_0/OUT_n.n20 vco_inductor_v2_0/VSUBS 1.04854f $ **FLOATING
C357 vco_core_0/OUT_n.n21 vco_inductor_v2_0/VSUBS 0.1107f $ **FLOATING
C358 vco_core_0/OUT_n.n23 vco_inductor_v2_0/VSUBS 0.1107f $ **FLOATING
C359 vco_core_0/OUT_n.n24 vco_inductor_v2_0/VSUBS 0.00183f $ **FLOATING
C360 vco_core_0/OUT_n.n26 vco_inductor_v2_0/VSUBS 0.10276f $ **FLOATING
C361 vco_core_0/OUT_n.n27 vco_inductor_v2_0/VSUBS 0.14091f $ **FLOATING
C362 vco_core_0/OUT_n.n28 vco_inductor_v2_0/VSUBS 0.07327f $ **FLOATING
C363 vco_core_0/OUT_n.n29 vco_inductor_v2_0/VSUBS 0.10029f $ **FLOATING
C364 vco_core_0/OUT_n.n30 vco_inductor_v2_0/VSUBS 0.00787f $ **FLOATING
C365 vco_core_0/OUT_n.n31 vco_inductor_v2_0/VSUBS 0.29598f $ **FLOATING
C366 vco_core_0/OUT_n.t6 vco_inductor_v2_0/VSUBS 0.03855f $ **FLOATING
C367 vco_core_0/OUT_n.t5 vco_inductor_v2_0/VSUBS 0.03855f $ **FLOATING
C368 vco_core_0/OUT_n.n32 vco_inductor_v2_0/VSUBS 0.15136f $ **FLOATING
C369 vco_core_0/OUT_n.t8 vco_inductor_v2_0/VSUBS 0.03855f $ **FLOATING
C370 vco_core_0/OUT_n.t7 vco_inductor_v2_0/VSUBS 0.03855f $ **FLOATING
C371 vco_core_0/OUT_n.n33 vco_inductor_v2_0/VSUBS 0.14832f $ **FLOATING
C372 vco_core_0/OUT_n.n34 vco_inductor_v2_0/VSUBS 0.28177f $ **FLOATING
C373 vco_core_0/OUT_n.t10 vco_inductor_v2_0/VSUBS 0.03855f $ **FLOATING
C374 vco_core_0/OUT_n.t9 vco_inductor_v2_0/VSUBS 0.03855f $ **FLOATING
C375 vco_core_0/OUT_n.n35 vco_inductor_v2_0/VSUBS 0.14832f $ **FLOATING
C376 vco_core_0/OUT_n.n36 vco_inductor_v2_0/VSUBS 0.17886f $ **FLOATING
C377 vco_core_0/OUT_n.t12 vco_inductor_v2_0/VSUBS 0.03855f $ **FLOATING
C378 vco_core_0/OUT_n.t11 vco_inductor_v2_0/VSUBS 0.03855f $ **FLOATING
C379 vco_core_0/OUT_n.n37 vco_inductor_v2_0/VSUBS 0.14832f $ **FLOATING
C380 vco_core_0/OUT_n.n38 vco_inductor_v2_0/VSUBS 0.17886f $ **FLOATING
C381 vco_core_0/OUT_n.t14 vco_inductor_v2_0/VSUBS 0.03855f $ **FLOATING
C382 vco_core_0/OUT_n.t13 vco_inductor_v2_0/VSUBS 0.03855f $ **FLOATING
C383 vco_core_0/OUT_n.n39 vco_inductor_v2_0/VSUBS 0.14832f $ **FLOATING
C384 vco_core_0/OUT_n.n40 vco_inductor_v2_0/VSUBS 0.13624f $ **FLOATING
C385 vco_core_0/OUT_n.n41 vco_inductor_v2_0/VSUBS 0.12233f $ **FLOATING
C386 vco_core_0/OUT_n.n42 vco_inductor_v2_0/VSUBS 0.09854f $ **FLOATING
C387 vco_core_0/OUT_n.n43 vco_inductor_v2_0/VSUBS 0.55386f $ **FLOATING
C388 vco_core_0/OUT_n.t29 vco_inductor_v2_0/VSUBS 0.21342f $ **FLOATING
C389 vco_core_0/OUT_n.t28 vco_inductor_v2_0/VSUBS 0.21342f $ **FLOATING
C390 vco_core_0/OUT_n.t27 vco_inductor_v2_0/VSUBS 0.21342f $ **FLOATING
C391 vco_core_0/OUT_n.t26 vco_inductor_v2_0/VSUBS 0.21342f $ **FLOATING
C392 vco_core_0/OUT_n.t25 vco_inductor_v2_0/VSUBS 0.22381f $ **FLOATING
C393 vco_core_0/OUT_n.n44 vco_inductor_v2_0/VSUBS 0.16177f $ **FLOATING
C394 vco_core_0/OUT_n.n45 vco_inductor_v2_0/VSUBS 0.0882f $ **FLOATING
C395 vco_core_0/OUT_n.n46 vco_inductor_v2_0/VSUBS 0.0882f $ **FLOATING
C396 vco_core_0/OUT_n.n47 vco_inductor_v2_0/VSUBS 0.12063f $ **FLOATING
C397 vco_core_0/OUT_n.t15 vco_inductor_v2_0/VSUBS 0.07376f $ **FLOATING
C398 vco_core_0/OUT_n.t16 vco_inductor_v2_0/VSUBS 0.06695f $ **FLOATING
C399 vco_core_0/OUT_n.n48 vco_inductor_v2_0/VSUBS 0.07048f $ **FLOATING
C400 vco_core_0/OUT_n.t17 vco_inductor_v2_0/VSUBS 0.06695f $ **FLOATING
C401 vco_core_0/OUT_n.n49 vco_inductor_v2_0/VSUBS 0.04076f $ **FLOATING
C402 vco_core_0/OUT_n.t18 vco_inductor_v2_0/VSUBS 0.06695f $ **FLOATING
C403 vco_core_0/OUT_n.n50 vco_inductor_v2_0/VSUBS 0.04076f $ **FLOATING
C404 vco_core_0/OUT_n.t19 vco_inductor_v2_0/VSUBS 0.06695f $ **FLOATING
C405 vco_core_0/OUT_n.n51 vco_inductor_v2_0/VSUBS 0.04076f $ **FLOATING
C406 vco_core_0/OUT_n.t20 vco_inductor_v2_0/VSUBS 0.06695f $ **FLOATING
C407 vco_core_0/OUT_n.n52 vco_inductor_v2_0/VSUBS 0.04076f $ **FLOATING
C408 vco_core_0/OUT_n.t21 vco_inductor_v2_0/VSUBS 0.06695f $ **FLOATING
C409 vco_core_0/OUT_n.n53 vco_inductor_v2_0/VSUBS 0.04076f $ **FLOATING
C410 vco_core_0/OUT_n.t22 vco_inductor_v2_0/VSUBS 0.06695f $ **FLOATING
C411 vco_core_0/OUT_n.n54 vco_inductor_v2_0/VSUBS 0.04076f $ **FLOATING
C412 vco_core_0/OUT_n.t23 vco_inductor_v2_0/VSUBS 0.06695f $ **FLOATING
C413 vco_core_0/OUT_n.n55 vco_inductor_v2_0/VSUBS 0.04076f $ **FLOATING
C414 vco_core_0/OUT_n.t24 vco_inductor_v2_0/VSUBS 0.06695f $ **FLOATING
C415 vco_core_0/OUT_n.n56 vco_inductor_v2_0/VSUBS 0.07479f $ **FLOATING
C416 vco_core_0/OUT_n.n57 vco_inductor_v2_0/VSUBS 5.57821f $ **FLOATING
C417 vco_core_0/OUT_n.n58 vco_inductor_v2_0/VSUBS 2.62247f $ **FLOATING
C418 vco_core_0/OUT_p.n1 vco_inductor_v2_0/VSUBS 0.10086f $ **FLOATING
C419 vco_core_0/OUT_p.t0 vco_inductor_v2_0/VSUBS 0.70059f $ **FLOATING
C420 vco_core_0/OUT_p.t5 vco_inductor_v2_0/VSUBS 0.14374f $ **FLOATING
C421 vco_core_0/OUT_p.t11 vco_inductor_v2_0/VSUBS 0.14374f $ **FLOATING
C422 vco_core_0/OUT_p.n2 vco_inductor_v2_0/VSUBS 0.50982f $ **FLOATING
C423 vco_core_0/OUT_p.n3 vco_inductor_v2_0/VSUBS 0.55558f $ **FLOATING
C424 vco_core_0/OUT_p.t7 vco_inductor_v2_0/VSUBS 0.14374f $ **FLOATING
C425 vco_core_0/OUT_p.t9 vco_inductor_v2_0/VSUBS 0.14374f $ **FLOATING
C426 vco_core_0/OUT_p.n4 vco_inductor_v2_0/VSUBS 0.50982f $ **FLOATING
C427 vco_core_0/OUT_p.n5 vco_inductor_v2_0/VSUBS 0.29571f $ **FLOATING
C428 vco_core_0/OUT_p.n6 vco_inductor_v2_0/VSUBS 0.33095f $ **FLOATING
C429 vco_core_0/OUT_p.n7 vco_inductor_v2_0/VSUBS 0.09193f $ **FLOATING
C430 vco_core_0/OUT_p.n8 vco_inductor_v2_0/VSUBS 0.01191f $ **FLOATING
C431 vco_core_0/OUT_p.n9 vco_inductor_v2_0/VSUBS 0.2538f $ **FLOATING
C432 vco_core_0/OUT_p.n10 vco_inductor_v2_0/VSUBS 0.08719f $ **FLOATING
C433 vco_core_0/OUT_p.n11 vco_inductor_v2_0/VSUBS 0.46982f $ **FLOATING
C434 vco_core_0/OUT_p.n12 vco_inductor_v2_0/VSUBS 1.11687f $ **FLOATING
C435 vco_core_0/OUT_p.n14 vco_inductor_v2_0/VSUBS 0.10496f $ **FLOATING
C436 vco_core_0/OUT_p.n15 vco_inductor_v2_0/VSUBS 0.11792f $ **FLOATING
C437 vco_core_0/OUT_p.t12 vco_inductor_v2_0/VSUBS 0.04107f $ **FLOATING
C438 vco_core_0/OUT_p.t13 vco_inductor_v2_0/VSUBS 0.04107f $ **FLOATING
C439 vco_core_0/OUT_p.n16 vco_inductor_v2_0/VSUBS 0.16122f $ **FLOATING
C440 vco_core_0/OUT_p.t8 vco_inductor_v2_0/VSUBS 0.04107f $ **FLOATING
C441 vco_core_0/OUT_p.t3 vco_inductor_v2_0/VSUBS 0.04107f $ **FLOATING
C442 vco_core_0/OUT_p.n17 vco_inductor_v2_0/VSUBS 0.15798f $ **FLOATING
C443 vco_core_0/OUT_p.n18 vco_inductor_v2_0/VSUBS 0.30013f $ **FLOATING
C444 vco_core_0/OUT_p.t4 vco_inductor_v2_0/VSUBS 0.04107f $ **FLOATING
C445 vco_core_0/OUT_p.t6 vco_inductor_v2_0/VSUBS 0.04107f $ **FLOATING
C446 vco_core_0/OUT_p.n19 vco_inductor_v2_0/VSUBS 0.15798f $ **FLOATING
C447 vco_core_0/OUT_p.n20 vco_inductor_v2_0/VSUBS 0.19051f $ **FLOATING
C448 vco_core_0/OUT_p.t2 vco_inductor_v2_0/VSUBS 0.04107f $ **FLOATING
C449 vco_core_0/OUT_p.t10 vco_inductor_v2_0/VSUBS 0.04107f $ **FLOATING
C450 vco_core_0/OUT_p.n21 vco_inductor_v2_0/VSUBS 0.15798f $ **FLOATING
C451 vco_core_0/OUT_p.n22 vco_inductor_v2_0/VSUBS 0.19051f $ **FLOATING
C452 vco_core_0/OUT_p.t1 vco_inductor_v2_0/VSUBS 0.04107f $ **FLOATING
C453 vco_core_0/OUT_p.t14 vco_inductor_v2_0/VSUBS 0.04107f $ **FLOATING
C454 vco_core_0/OUT_p.n23 vco_inductor_v2_0/VSUBS 0.15798f $ **FLOATING
C455 vco_core_0/OUT_p.n24 vco_inductor_v2_0/VSUBS 0.14512f $ **FLOATING
C456 vco_core_0/OUT_p.n25 vco_inductor_v2_0/VSUBS 0.11792f $ **FLOATING
C457 vco_core_0/OUT_p.n26 vco_inductor_v2_0/VSUBS 0.00195f $ **FLOATING
C458 vco_core_0/OUT_p.n28 vco_inductor_v2_0/VSUBS 0.07804f $ **FLOATING
C459 vco_core_0/OUT_p.n29 vco_inductor_v2_0/VSUBS 0.1501f $ **FLOATING
C460 vco_core_0/OUT_p.n30 vco_inductor_v2_0/VSUBS 0.10946f $ **FLOATING
C461 vco_core_0/OUT_p.n31 vco_inductor_v2_0/VSUBS 0.13138f $ **FLOATING
C462 vco_core_0/OUT_p.n32 vco_inductor_v2_0/VSUBS 0.26015f $ **FLOATING
C463 vco_core_0/OUT_p.t29 vco_inductor_v2_0/VSUBS 0.22732f $ **FLOATING
C464 vco_core_0/OUT_p.t28 vco_inductor_v2_0/VSUBS 0.22732f $ **FLOATING
C465 vco_core_0/OUT_p.t27 vco_inductor_v2_0/VSUBS 0.22732f $ **FLOATING
C466 vco_core_0/OUT_p.t26 vco_inductor_v2_0/VSUBS 0.22732f $ **FLOATING
C467 vco_core_0/OUT_p.t25 vco_inductor_v2_0/VSUBS 0.23839f $ **FLOATING
C468 vco_core_0/OUT_p.n33 vco_inductor_v2_0/VSUBS 0.17231f $ **FLOATING
C469 vco_core_0/OUT_p.n34 vco_inductor_v2_0/VSUBS 0.09395f $ **FLOATING
C470 vco_core_0/OUT_p.n35 vco_inductor_v2_0/VSUBS 0.09395f $ **FLOATING
C471 vco_core_0/OUT_p.n36 vco_inductor_v2_0/VSUBS 0.13306f $ **FLOATING
C472 vco_core_0/OUT_p.t15 vco_inductor_v2_0/VSUBS 0.07856f $ **FLOATING
C473 vco_core_0/OUT_p.t16 vco_inductor_v2_0/VSUBS 0.07131f $ **FLOATING
C474 vco_core_0/OUT_p.n37 vco_inductor_v2_0/VSUBS 0.07508f $ **FLOATING
C475 vco_core_0/OUT_p.t17 vco_inductor_v2_0/VSUBS 0.07131f $ **FLOATING
C476 vco_core_0/OUT_p.n38 vco_inductor_v2_0/VSUBS 0.04342f $ **FLOATING
C477 vco_core_0/OUT_p.t18 vco_inductor_v2_0/VSUBS 0.07131f $ **FLOATING
C478 vco_core_0/OUT_p.n39 vco_inductor_v2_0/VSUBS 0.04342f $ **FLOATING
C479 vco_core_0/OUT_p.t19 vco_inductor_v2_0/VSUBS 0.07131f $ **FLOATING
C480 vco_core_0/OUT_p.n40 vco_inductor_v2_0/VSUBS 0.04342f $ **FLOATING
C481 vco_core_0/OUT_p.t20 vco_inductor_v2_0/VSUBS 0.07131f $ **FLOATING
C482 vco_core_0/OUT_p.n41 vco_inductor_v2_0/VSUBS 0.04342f $ **FLOATING
C483 vco_core_0/OUT_p.t21 vco_inductor_v2_0/VSUBS 0.07131f $ **FLOATING
C484 vco_core_0/OUT_p.n42 vco_inductor_v2_0/VSUBS 0.04342f $ **FLOATING
C485 vco_core_0/OUT_p.t22 vco_inductor_v2_0/VSUBS 0.07131f $ **FLOATING
C486 vco_core_0/OUT_p.n43 vco_inductor_v2_0/VSUBS 0.04342f $ **FLOATING
C487 vco_core_0/OUT_p.t23 vco_inductor_v2_0/VSUBS 0.07131f $ **FLOATING
C488 vco_core_0/OUT_p.n44 vco_inductor_v2_0/VSUBS 0.04342f $ **FLOATING
C489 vco_core_0/OUT_p.t24 vco_inductor_v2_0/VSUBS 0.07131f $ **FLOATING
C490 vco_core_0/OUT_p.n45 vco_inductor_v2_0/VSUBS 0.07178f $ **FLOATING
C491 vco_core_0/OUT_p.n46 vco_inductor_v2_0/VSUBS 5.82049f $ **FLOATING
C492 vco_core_0/OUT_p.n47 vco_inductor_v2_0/VSUBS 2.6967f $ **FLOATING
C493 vco_core_0/ISS.t0 vco_inductor_v2_0/VSUBS 0.47371f $ **FLOATING
C494 vco_core_0/ISS.t14 vco_inductor_v2_0/VSUBS 0.08773f $ **FLOATING
C495 vco_core_0/ISS.t15 vco_inductor_v2_0/VSUBS 0.08773f $ **FLOATING
C496 vco_core_0/ISS.n0 vco_inductor_v2_0/VSUBS 0.36421f $ **FLOATING
C497 vco_core_0/ISS.n1 vco_inductor_v2_0/VSUBS 0.28204f $ **FLOATING
C498 vco_core_0/ISS.t7 vco_inductor_v2_0/VSUBS 0.08773f $ **FLOATING
C499 vco_core_0/ISS.t9 vco_inductor_v2_0/VSUBS 0.08773f $ **FLOATING
C500 vco_core_0/ISS.n2 vco_inductor_v2_0/VSUBS 0.36421f $ **FLOATING
C501 vco_core_0/ISS.n3 vco_inductor_v2_0/VSUBS 0.1211f $ **FLOATING
C502 vco_core_0/ISS.t8 vco_inductor_v2_0/VSUBS 0.08773f $ **FLOATING
C503 vco_core_0/ISS.t3 vco_inductor_v2_0/VSUBS 0.08773f $ **FLOATING
C504 vco_core_0/ISS.n4 vco_inductor_v2_0/VSUBS 0.36421f $ **FLOATING
C505 vco_core_0/ISS.n5 vco_inductor_v2_0/VSUBS 0.1211f $ **FLOATING
C506 vco_core_0/ISS.t4 vco_inductor_v2_0/VSUBS 0.08773f $ **FLOATING
C507 vco_core_0/ISS.t19 vco_inductor_v2_0/VSUBS 0.08773f $ **FLOATING
C508 vco_core_0/ISS.n6 vco_inductor_v2_0/VSUBS 0.36421f $ **FLOATING
C509 vco_core_0/ISS.n7 vco_inductor_v2_0/VSUBS 0.1211f $ **FLOATING
C510 vco_core_0/ISS.t12 vco_inductor_v2_0/VSUBS 0.46136f $ **FLOATING
C511 vco_core_0/ISS.n8 vco_inductor_v2_0/VSUBS 0.27296f $ **FLOATING
C512 vco_core_0/ISS.t16 vco_inductor_v2_0/VSUBS 0.46136f $ **FLOATING
C513 vco_core_0/ISS.n9 vco_inductor_v2_0/VSUBS 0.24934f $ **FLOATING
C514 vco_core_0/ISS.t18 vco_inductor_v2_0/VSUBS 0.47371f $ **FLOATING
C515 vco_core_0/ISS.t13 vco_inductor_v2_0/VSUBS 0.08773f $ **FLOATING
C516 vco_core_0/ISS.t1 vco_inductor_v2_0/VSUBS 0.08773f $ **FLOATING
C517 vco_core_0/ISS.n10 vco_inductor_v2_0/VSUBS 0.36421f $ **FLOATING
C518 vco_core_0/ISS.n11 vco_inductor_v2_0/VSUBS 0.28204f $ **FLOATING
C519 vco_core_0/ISS.t10 vco_inductor_v2_0/VSUBS 0.08773f $ **FLOATING
C520 vco_core_0/ISS.t2 vco_inductor_v2_0/VSUBS 0.08773f $ **FLOATING
C521 vco_core_0/ISS.n12 vco_inductor_v2_0/VSUBS 0.36421f $ **FLOATING
C522 vco_core_0/ISS.n13 vco_inductor_v2_0/VSUBS 0.1211f $ **FLOATING
C523 vco_core_0/ISS.t5 vco_inductor_v2_0/VSUBS 0.08773f $ **FLOATING
C524 vco_core_0/ISS.t6 vco_inductor_v2_0/VSUBS 0.08773f $ **FLOATING
C525 vco_core_0/ISS.n14 vco_inductor_v2_0/VSUBS 0.36421f $ **FLOATING
C526 vco_core_0/ISS.n15 vco_inductor_v2_0/VSUBS 0.1211f $ **FLOATING
C527 vco_core_0/ISS.t17 vco_inductor_v2_0/VSUBS 0.08773f $ **FLOATING
C528 vco_core_0/ISS.t11 vco_inductor_v2_0/VSUBS 0.08773f $ **FLOATING
C529 vco_core_0/ISS.n16 vco_inductor_v2_0/VSUBS 0.36421f $ **FLOATING
C530 vco_core_0/ISS.n17 vco_inductor_v2_0/VSUBS 0.10693f $ **FLOATING
C534 OUT_p vco_inductor_v2_0/VSUBS 0.14162p
C535 OUT_n vco_inductor_v2_0/VSUBS 0.13661p
C536 vco_varactors_0/OUT_n.n0 vco_inductor_v2_0/VSUBS 0.04831f $ **FLOATING
C537 vco_varactors_0/OUT_n.n1 vco_inductor_v2_0/VSUBS 0.01024f $ **FLOATING
C538 vco_varactors_0/OUT_n.n2 vco_inductor_v2_0/VSUBS 0.0476f $ **FLOATING
C539 vco_varactors_0/OUT_n.n4 vco_inductor_v2_0/VSUBS 0.0541f $ **FLOATING
C540 vco_varactors_0/OUT_n.t1 vco_inductor_v2_0/VSUBS 1.41807f $ **FLOATING
C541 vco_varactors_0/OUT_n.t4 vco_inductor_v2_0/VSUBS 1.3645f $ **FLOATING
C542 vco_varactors_0/OUT_n.n5 vco_inductor_v2_0/VSUBS 0.65075f $ **FLOATING
C543 vco_varactors_0/OUT_n.t7 vco_inductor_v2_0/VSUBS 1.3645f $ **FLOATING
C544 vco_varactors_0/OUT_n.n6 vco_inductor_v2_0/VSUBS 0.41511f $ **FLOATING
C545 vco_varactors_0/OUT_n.t10 vco_inductor_v2_0/VSUBS 1.3645f $ **FLOATING
C546 vco_varactors_0/OUT_n.n7 vco_inductor_v2_0/VSUBS 0.41511f $ **FLOATING
C547 vco_varactors_0/OUT_n.t13 vco_inductor_v2_0/VSUBS 1.3645f $ **FLOATING
C548 vco_varactors_0/OUT_n.n8 vco_inductor_v2_0/VSUBS 0.41511f $ **FLOATING
C549 vco_varactors_0/OUT_n.t16 vco_inductor_v2_0/VSUBS 1.3645f $ **FLOATING
C550 vco_varactors_0/OUT_n.n9 vco_inductor_v2_0/VSUBS 0.41511f $ **FLOATING
C551 vco_varactors_0/OUT_n.t19 vco_inductor_v2_0/VSUBS 1.3645f $ **FLOATING
C552 vco_varactors_0/OUT_n.n10 vco_inductor_v2_0/VSUBS 0.32874f $ **FLOATING
C553 vco_varactors_0/OUT_n.n11 vco_inductor_v2_0/VSUBS 0.11964f $ **FLOATING
C554 vco_varactors_0/OUT_n.n13 vco_inductor_v2_0/VSUBS 0.05376f $ **FLOATING
C555 vco_varactors_0/OUT_n.n14 vco_inductor_v2_0/VSUBS 0.04736f $ **FLOATING
C556 vco_varactors_0/OUT_n.n18 vco_inductor_v2_0/VSUBS 0 $ **FLOATING
C557 vco_varactors_0/OUT_n.n19 vco_inductor_v2_0/VSUBS 0.12379f $ **FLOATING
C558 vco_varactors_0/OUT_n.n20 vco_inductor_v2_0/VSUBS 0.05376f $ **FLOATING
C559 vco_varactors_0/OUT_n.t2 vco_inductor_v2_0/VSUBS 1.41807f $ **FLOATING
C560 vco_varactors_0/OUT_n.t5 vco_inductor_v2_0/VSUBS 1.3645f $ **FLOATING
C561 vco_varactors_0/OUT_n.n21 vco_inductor_v2_0/VSUBS 0.65075f $ **FLOATING
C562 vco_varactors_0/OUT_n.t8 vco_inductor_v2_0/VSUBS 1.3645f $ **FLOATING
C563 vco_varactors_0/OUT_n.n22 vco_inductor_v2_0/VSUBS 0.41511f $ **FLOATING
C564 vco_varactors_0/OUT_n.t11 vco_inductor_v2_0/VSUBS 1.3645f $ **FLOATING
C565 vco_varactors_0/OUT_n.n23 vco_inductor_v2_0/VSUBS 0.41511f $ **FLOATING
C566 vco_varactors_0/OUT_n.t14 vco_inductor_v2_0/VSUBS 1.3645f $ **FLOATING
C567 vco_varactors_0/OUT_n.n24 vco_inductor_v2_0/VSUBS 0.41511f $ **FLOATING
C568 vco_varactors_0/OUT_n.t17 vco_inductor_v2_0/VSUBS 1.3645f $ **FLOATING
C569 vco_varactors_0/OUT_n.n25 vco_inductor_v2_0/VSUBS 0.41511f $ **FLOATING
C570 vco_varactors_0/OUT_n.t20 vco_inductor_v2_0/VSUBS 1.3645f $ **FLOATING
C571 vco_varactors_0/OUT_n.n26 vco_inductor_v2_0/VSUBS 0.32874f $ **FLOATING
C572 vco_varactors_0/OUT_n.n27 vco_inductor_v2_0/VSUBS 0.12013f $ **FLOATING
C573 vco_varactors_0/OUT_n.n28 vco_inductor_v2_0/VSUBS 0 $ **FLOATING
C574 vco_varactors_0/OUT_n.n29 vco_inductor_v2_0/VSUBS 0.05376f $ **FLOATING
C575 vco_varactors_0/OUT_n.n30 vco_inductor_v2_0/VSUBS 0.0277f $ **FLOATING
C576 vco_varactors_0/OUT_n.n31 vco_inductor_v2_0/VSUBS 0.04786f $ **FLOATING
C577 vco_varactors_0/OUT_n.n32 vco_inductor_v2_0/VSUBS 0.28082f $ **FLOATING
C578 vco_varactors_0/OUT_n.n34 vco_inductor_v2_0/VSUBS 0.0541f $ **FLOATING
C579 vco_varactors_0/OUT_n.n36 vco_inductor_v2_0/VSUBS 0.28082f $ **FLOATING
C580 vco_varactors_0/OUT_n.n37 vco_inductor_v2_0/VSUBS 0.05376f $ **FLOATING
C581 vco_varactors_0/OUT_n.n39 vco_inductor_v2_0/VSUBS 0.28082f $ **FLOATING
C582 vco_varactors_0/OUT_n.n41 vco_inductor_v2_0/VSUBS 0.0541f $ **FLOATING
C583 vco_varactors_0/OUT_n.t0 vco_inductor_v2_0/VSUBS 1.41807f $ **FLOATING
C584 vco_varactors_0/OUT_n.t3 vco_inductor_v2_0/VSUBS 1.3645f $ **FLOATING
C585 vco_varactors_0/OUT_n.n43 vco_inductor_v2_0/VSUBS 0.65075f $ **FLOATING
C586 vco_varactors_0/OUT_n.t6 vco_inductor_v2_0/VSUBS 1.3645f $ **FLOATING
C587 vco_varactors_0/OUT_n.n44 vco_inductor_v2_0/VSUBS 0.41511f $ **FLOATING
C588 vco_varactors_0/OUT_n.t9 vco_inductor_v2_0/VSUBS 1.3645f $ **FLOATING
C589 vco_varactors_0/OUT_n.n45 vco_inductor_v2_0/VSUBS 0.41511f $ **FLOATING
C590 vco_varactors_0/OUT_n.t12 vco_inductor_v2_0/VSUBS 1.3645f $ **FLOATING
C591 vco_varactors_0/OUT_n.n46 vco_inductor_v2_0/VSUBS 0.41511f $ **FLOATING
C592 vco_varactors_0/OUT_n.t15 vco_inductor_v2_0/VSUBS 1.3645f $ **FLOATING
C593 vco_varactors_0/OUT_n.n47 vco_inductor_v2_0/VSUBS 0.41511f $ **FLOATING
C594 vco_varactors_0/OUT_n.t18 vco_inductor_v2_0/VSUBS 1.3645f $ **FLOATING
C595 vco_varactors_0/OUT_n.n48 vco_inductor_v2_0/VSUBS 0.32874f $ **FLOATING
C596 vco_varactors_0/OUT_n.n49 vco_inductor_v2_0/VSUBS 0.11988f $ **FLOATING
C597 vco_varactors_0/OUT_n.n51 vco_inductor_v2_0/VSUBS 0.05376f $ **FLOATING
C598 vco_varactors_0/OUT_n.n52 vco_inductor_v2_0/VSUBS 0.28082f $ **FLOATING
C599 vco_varactors_0/OUT_n.n53 vco_inductor_v2_0/VSUBS 0.05376f $ **FLOATING
C600 vco_varactors_0/OUT_n.n54 vco_inductor_v2_0/VSUBS 0 $ **FLOATING
C601 vco_varactors_0/OUT_n.n55 vco_inductor_v2_0/VSUBS 0.01689f $ **FLOATING
C602 vco_varactors_0/OUT_p.n0 vco_inductor_v2_0/VSUBS 0.04943f $ **FLOATING
C603 vco_varactors_0/OUT_p.n1 vco_inductor_v2_0/VSUBS 0.01048f $ **FLOATING
C604 vco_varactors_0/OUT_p.n2 vco_inductor_v2_0/VSUBS 0.04872f $ **FLOATING
C605 vco_varactors_0/OUT_p.n4 vco_inductor_v2_0/VSUBS 0.05537f $ **FLOATING
C606 vco_varactors_0/OUT_p.t1 vco_inductor_v2_0/VSUBS 1.45119f $ **FLOATING
C607 vco_varactors_0/OUT_p.t4 vco_inductor_v2_0/VSUBS 1.39637f $ **FLOATING
C608 vco_varactors_0/OUT_p.n5 vco_inductor_v2_0/VSUBS 0.66595f $ **FLOATING
C609 vco_varactors_0/OUT_p.t7 vco_inductor_v2_0/VSUBS 1.39637f $ **FLOATING
C610 vco_varactors_0/OUT_p.n6 vco_inductor_v2_0/VSUBS 0.4248f $ **FLOATING
C611 vco_varactors_0/OUT_p.t10 vco_inductor_v2_0/VSUBS 1.39637f $ **FLOATING
C612 vco_varactors_0/OUT_p.n7 vco_inductor_v2_0/VSUBS 0.4248f $ **FLOATING
C613 vco_varactors_0/OUT_p.t13 vco_inductor_v2_0/VSUBS 1.39637f $ **FLOATING
C614 vco_varactors_0/OUT_p.n8 vco_inductor_v2_0/VSUBS 0.4248f $ **FLOATING
C615 vco_varactors_0/OUT_p.t16 vco_inductor_v2_0/VSUBS 1.39637f $ **FLOATING
C616 vco_varactors_0/OUT_p.n9 vco_inductor_v2_0/VSUBS 0.4248f $ **FLOATING
C617 vco_varactors_0/OUT_p.t19 vco_inductor_v2_0/VSUBS 1.39637f $ **FLOATING
C618 vco_varactors_0/OUT_p.n10 vco_inductor_v2_0/VSUBS 0.33642f $ **FLOATING
C619 vco_varactors_0/OUT_p.n11 vco_inductor_v2_0/VSUBS 0.12243f $ **FLOATING
C620 vco_varactors_0/OUT_p.n13 vco_inductor_v2_0/VSUBS 0.05502f $ **FLOATING
C621 vco_varactors_0/OUT_p.n14 vco_inductor_v2_0/VSUBS 0.04847f $ **FLOATING
C622 vco_varactors_0/OUT_p.n18 vco_inductor_v2_0/VSUBS 0 $ **FLOATING
C623 vco_varactors_0/OUT_p.n19 vco_inductor_v2_0/VSUBS 0.12669f $ **FLOATING
C624 vco_varactors_0/OUT_p.n20 vco_inductor_v2_0/VSUBS 0.05502f $ **FLOATING
C625 vco_varactors_0/OUT_p.t2 vco_inductor_v2_0/VSUBS 1.45119f $ **FLOATING
C626 vco_varactors_0/OUT_p.t5 vco_inductor_v2_0/VSUBS 1.39637f $ **FLOATING
C627 vco_varactors_0/OUT_p.n21 vco_inductor_v2_0/VSUBS 0.66595f $ **FLOATING
C628 vco_varactors_0/OUT_p.t8 vco_inductor_v2_0/VSUBS 1.39637f $ **FLOATING
C629 vco_varactors_0/OUT_p.n22 vco_inductor_v2_0/VSUBS 0.4248f $ **FLOATING
C630 vco_varactors_0/OUT_p.t11 vco_inductor_v2_0/VSUBS 1.39637f $ **FLOATING
C631 vco_varactors_0/OUT_p.n23 vco_inductor_v2_0/VSUBS 0.4248f $ **FLOATING
C632 vco_varactors_0/OUT_p.t14 vco_inductor_v2_0/VSUBS 1.39637f $ **FLOATING
C633 vco_varactors_0/OUT_p.n24 vco_inductor_v2_0/VSUBS 0.4248f $ **FLOATING
C634 vco_varactors_0/OUT_p.t17 vco_inductor_v2_0/VSUBS 1.39637f $ **FLOATING
C635 vco_varactors_0/OUT_p.n25 vco_inductor_v2_0/VSUBS 0.4248f $ **FLOATING
C636 vco_varactors_0/OUT_p.t20 vco_inductor_v2_0/VSUBS 1.39637f $ **FLOATING
C637 vco_varactors_0/OUT_p.n26 vco_inductor_v2_0/VSUBS 0.33642f $ **FLOATING
C638 vco_varactors_0/OUT_p.n27 vco_inductor_v2_0/VSUBS 0.12293f $ **FLOATING
C639 vco_varactors_0/OUT_p.n28 vco_inductor_v2_0/VSUBS 0 $ **FLOATING
C640 vco_varactors_0/OUT_p.n29 vco_inductor_v2_0/VSUBS 0.05502f $ **FLOATING
C641 vco_varactors_0/OUT_p.n30 vco_inductor_v2_0/VSUBS 0.02834f $ **FLOATING
C642 vco_varactors_0/OUT_p.n31 vco_inductor_v2_0/VSUBS 0.04897f $ **FLOATING
C643 vco_varactors_0/OUT_p.n32 vco_inductor_v2_0/VSUBS 0.28738f $ **FLOATING
C644 vco_varactors_0/OUT_p.n34 vco_inductor_v2_0/VSUBS 0.05537f $ **FLOATING
C645 vco_varactors_0/OUT_p.n36 vco_inductor_v2_0/VSUBS 0.28738f $ **FLOATING
C646 vco_varactors_0/OUT_p.n37 vco_inductor_v2_0/VSUBS 0.05502f $ **FLOATING
C647 vco_varactors_0/OUT_p.n39 vco_inductor_v2_0/VSUBS 0.28738f $ **FLOATING
C648 vco_varactors_0/OUT_p.n41 vco_inductor_v2_0/VSUBS 0.05537f $ **FLOATING
C649 vco_varactors_0/OUT_p.t0 vco_inductor_v2_0/VSUBS 1.45119f $ **FLOATING
C650 vco_varactors_0/OUT_p.t3 vco_inductor_v2_0/VSUBS 1.39637f $ **FLOATING
C651 vco_varactors_0/OUT_p.n43 vco_inductor_v2_0/VSUBS 0.66595f $ **FLOATING
C652 vco_varactors_0/OUT_p.t6 vco_inductor_v2_0/VSUBS 1.39637f $ **FLOATING
C653 vco_varactors_0/OUT_p.n44 vco_inductor_v2_0/VSUBS 0.4248f $ **FLOATING
C654 vco_varactors_0/OUT_p.t9 vco_inductor_v2_0/VSUBS 1.39637f $ **FLOATING
C655 vco_varactors_0/OUT_p.n45 vco_inductor_v2_0/VSUBS 0.4248f $ **FLOATING
C656 vco_varactors_0/OUT_p.t12 vco_inductor_v2_0/VSUBS 1.39637f $ **FLOATING
C657 vco_varactors_0/OUT_p.n46 vco_inductor_v2_0/VSUBS 0.4248f $ **FLOATING
C658 vco_varactors_0/OUT_p.t15 vco_inductor_v2_0/VSUBS 1.39637f $ **FLOATING
C659 vco_varactors_0/OUT_p.n47 vco_inductor_v2_0/VSUBS 0.4248f $ **FLOATING
C660 vco_varactors_0/OUT_p.t18 vco_inductor_v2_0/VSUBS 1.39637f $ **FLOATING
C661 vco_varactors_0/OUT_p.n48 vco_inductor_v2_0/VSUBS 0.33642f $ **FLOATING
C662 vco_varactors_0/OUT_p.n49 vco_inductor_v2_0/VSUBS 0.12268f $ **FLOATING
C663 vco_varactors_0/OUT_p.n51 vco_inductor_v2_0/VSUBS 0.05502f $ **FLOATING
C664 vco_varactors_0/OUT_p.n52 vco_inductor_v2_0/VSUBS 0.28738f $ **FLOATING
C665 vco_varactors_0/OUT_p.n53 vco_inductor_v2_0/VSUBS 0.05502f $ **FLOATING
C666 vco_varactors_0/OUT_p.n54 vco_inductor_v2_0/VSUBS 0 $ **FLOATING
C667 vco_varactors_0/OUT_p.n55 vco_inductor_v2_0/VSUBS 0.01728f $ **FLOATING
C668 vco_varactors_0/cap_bias.n0 vco_inductor_v2_0/VSUBS 0.06597f $ **FLOATING
C669 vco_varactors_0/cap_bias.n1 vco_inductor_v2_0/VSUBS 0.04263f $ **FLOATING
C670 vco_varactors_0/cap_bias.n2 vco_inductor_v2_0/VSUBS 0.17429f $ **FLOATING
C671 vco_varactors_0/cap_bias.n4 vco_inductor_v2_0/VSUBS 0.07107f $ **FLOATING
C672 vco_varactors_0/cap_bias.n6 vco_inductor_v2_0/VSUBS 0.03779f $ **FLOATING
C673 vco_varactors_0/cap_bias.t4 vco_inductor_v2_0/VSUBS 1.11454f $ **FLOATING
C674 vco_varactors_0/cap_bias.t10 vco_inductor_v2_0/VSUBS 1.04297f $ **FLOATING
C675 vco_varactors_0/cap_bias.n8 vco_inductor_v2_0/VSUBS 1.29849f $ **FLOATING
C676 vco_varactors_0/cap_bias.t16 vco_inductor_v2_0/VSUBS 1.04297f $ **FLOATING
C677 vco_varactors_0/cap_bias.n9 vco_inductor_v2_0/VSUBS 0.7073f $ **FLOATING
C678 vco_varactors_0/cap_bias.t22 vco_inductor_v2_0/VSUBS 1.04297f $ **FLOATING
C679 vco_varactors_0/cap_bias.n10 vco_inductor_v2_0/VSUBS 0.7073f $ **FLOATING
C680 vco_varactors_0/cap_bias.t28 vco_inductor_v2_0/VSUBS 1.04297f $ **FLOATING
C681 vco_varactors_0/cap_bias.n11 vco_inductor_v2_0/VSUBS 0.7073f $ **FLOATING
C682 vco_varactors_0/cap_bias.t34 vco_inductor_v2_0/VSUBS 1.04297f $ **FLOATING
C683 vco_varactors_0/cap_bias.n12 vco_inductor_v2_0/VSUBS 0.50069f $ **FLOATING
C684 vco_varactors_0/cap_bias.n13 vco_inductor_v2_0/VSUBS 0.52005f $ **FLOATING
C685 vco_varactors_0/cap_bias.n14 vco_inductor_v2_0/VSUBS 0.07197f $ **FLOATING
C686 vco_varactors_0/cap_bias.n15 vco_inductor_v2_0/VSUBS 0.07107f $ **FLOATING
C687 vco_varactors_0/cap_bias.n17 vco_inductor_v2_0/VSUBS 0.03779f $ **FLOATING
C688 vco_varactors_0/cap_bias.t3 vco_inductor_v2_0/VSUBS 1.11454f $ **FLOATING
C689 vco_varactors_0/cap_bias.t9 vco_inductor_v2_0/VSUBS 1.04297f $ **FLOATING
C690 vco_varactors_0/cap_bias.n19 vco_inductor_v2_0/VSUBS 1.29849f $ **FLOATING
C691 vco_varactors_0/cap_bias.t15 vco_inductor_v2_0/VSUBS 1.04297f $ **FLOATING
C692 vco_varactors_0/cap_bias.n20 vco_inductor_v2_0/VSUBS 0.7073f $ **FLOATING
C693 vco_varactors_0/cap_bias.t21 vco_inductor_v2_0/VSUBS 1.04297f $ **FLOATING
C694 vco_varactors_0/cap_bias.n21 vco_inductor_v2_0/VSUBS 0.7073f $ **FLOATING
C695 vco_varactors_0/cap_bias.t27 vco_inductor_v2_0/VSUBS 1.04297f $ **FLOATING
C696 vco_varactors_0/cap_bias.n22 vco_inductor_v2_0/VSUBS 0.7073f $ **FLOATING
C697 vco_varactors_0/cap_bias.t33 vco_inductor_v2_0/VSUBS 1.04297f $ **FLOATING
C698 vco_varactors_0/cap_bias.n23 vco_inductor_v2_0/VSUBS 0.50069f $ **FLOATING
C699 vco_varactors_0/cap_bias.n24 vco_inductor_v2_0/VSUBS 0.52005f $ **FLOATING
C700 vco_varactors_0/cap_bias.n25 vco_inductor_v2_0/VSUBS 0.07197f $ **FLOATING
C701 vco_varactors_0/cap_bias.n26 vco_inductor_v2_0/VSUBS 0.07107f $ **FLOATING
C702 vco_varactors_0/cap_bias.n28 vco_inductor_v2_0/VSUBS 0.03779f $ **FLOATING
C703 vco_varactors_0/cap_bias.t2 vco_inductor_v2_0/VSUBS 1.11454f $ **FLOATING
C704 vco_varactors_0/cap_bias.t8 vco_inductor_v2_0/VSUBS 1.04297f $ **FLOATING
C705 vco_varactors_0/cap_bias.n30 vco_inductor_v2_0/VSUBS 1.29849f $ **FLOATING
C706 vco_varactors_0/cap_bias.t14 vco_inductor_v2_0/VSUBS 1.04297f $ **FLOATING
C707 vco_varactors_0/cap_bias.n31 vco_inductor_v2_0/VSUBS 0.7073f $ **FLOATING
C708 vco_varactors_0/cap_bias.t20 vco_inductor_v2_0/VSUBS 1.04297f $ **FLOATING
C709 vco_varactors_0/cap_bias.n32 vco_inductor_v2_0/VSUBS 0.7073f $ **FLOATING
C710 vco_varactors_0/cap_bias.t26 vco_inductor_v2_0/VSUBS 1.04297f $ **FLOATING
C711 vco_varactors_0/cap_bias.n33 vco_inductor_v2_0/VSUBS 0.7073f $ **FLOATING
C712 vco_varactors_0/cap_bias.t32 vco_inductor_v2_0/VSUBS 1.04297f $ **FLOATING
C713 vco_varactors_0/cap_bias.n34 vco_inductor_v2_0/VSUBS 0.50069f $ **FLOATING
C714 vco_varactors_0/cap_bias.n35 vco_inductor_v2_0/VSUBS 0.52005f $ **FLOATING
C715 vco_varactors_0/cap_bias.n36 vco_inductor_v2_0/VSUBS 0.07197f $ **FLOATING
C716 vco_varactors_0/cap_bias.n37 vco_inductor_v2_0/VSUBS 0.07107f $ **FLOATING
C717 vco_varactors_0/cap_bias.n39 vco_inductor_v2_0/VSUBS 0.03779f $ **FLOATING
C718 vco_varactors_0/cap_bias.t1 vco_inductor_v2_0/VSUBS 1.11454f $ **FLOATING
C719 vco_varactors_0/cap_bias.t7 vco_inductor_v2_0/VSUBS 1.04297f $ **FLOATING
C720 vco_varactors_0/cap_bias.n41 vco_inductor_v2_0/VSUBS 1.29849f $ **FLOATING
C721 vco_varactors_0/cap_bias.t13 vco_inductor_v2_0/VSUBS 1.04297f $ **FLOATING
C722 vco_varactors_0/cap_bias.n42 vco_inductor_v2_0/VSUBS 0.7073f $ **FLOATING
C723 vco_varactors_0/cap_bias.t19 vco_inductor_v2_0/VSUBS 1.04297f $ **FLOATING
C724 vco_varactors_0/cap_bias.n43 vco_inductor_v2_0/VSUBS 0.7073f $ **FLOATING
C725 vco_varactors_0/cap_bias.t25 vco_inductor_v2_0/VSUBS 1.04297f $ **FLOATING
C726 vco_varactors_0/cap_bias.n44 vco_inductor_v2_0/VSUBS 0.7073f $ **FLOATING
C727 vco_varactors_0/cap_bias.t31 vco_inductor_v2_0/VSUBS 1.04297f $ **FLOATING
C728 vco_varactors_0/cap_bias.n45 vco_inductor_v2_0/VSUBS 0.50069f $ **FLOATING
C729 vco_varactors_0/cap_bias.n46 vco_inductor_v2_0/VSUBS 0.52005f $ **FLOATING
C730 vco_varactors_0/cap_bias.n47 vco_inductor_v2_0/VSUBS 0.07197f $ **FLOATING
C731 vco_varactors_0/cap_bias.n48 vco_inductor_v2_0/VSUBS 0.07107f $ **FLOATING
C732 vco_varactors_0/cap_bias.n50 vco_inductor_v2_0/VSUBS 0.03779f $ **FLOATING
C733 vco_varactors_0/cap_bias.n51 vco_inductor_v2_0/VSUBS 0.00117f $ **FLOATING
C734 vco_varactors_0/cap_bias.t0 vco_inductor_v2_0/VSUBS 1.11454f $ **FLOATING
C735 vco_varactors_0/cap_bias.t6 vco_inductor_v2_0/VSUBS 1.04297f $ **FLOATING
C736 vco_varactors_0/cap_bias.n52 vco_inductor_v2_0/VSUBS 1.29849f $ **FLOATING
C737 vco_varactors_0/cap_bias.t12 vco_inductor_v2_0/VSUBS 1.04297f $ **FLOATING
C738 vco_varactors_0/cap_bias.n53 vco_inductor_v2_0/VSUBS 0.7073f $ **FLOATING
C739 vco_varactors_0/cap_bias.t18 vco_inductor_v2_0/VSUBS 1.04297f $ **FLOATING
C740 vco_varactors_0/cap_bias.n54 vco_inductor_v2_0/VSUBS 0.7073f $ **FLOATING
C741 vco_varactors_0/cap_bias.t24 vco_inductor_v2_0/VSUBS 1.04297f $ **FLOATING
C742 vco_varactors_0/cap_bias.n55 vco_inductor_v2_0/VSUBS 0.7073f $ **FLOATING
C743 vco_varactors_0/cap_bias.t30 vco_inductor_v2_0/VSUBS 1.04297f $ **FLOATING
C744 vco_varactors_0/cap_bias.n56 vco_inductor_v2_0/VSUBS 0.50069f $ **FLOATING
C745 vco_varactors_0/cap_bias.n57 vco_inductor_v2_0/VSUBS 0.52005f $ **FLOATING
C746 vco_varactors_0/cap_bias.t36 vco_inductor_v2_0/VSUBS 1.04297f $ **FLOATING
C747 vco_varactors_0/cap_bias.n58 vco_inductor_v2_0/VSUBS 0.175f $ **FLOATING
C748 vco_varactors_0/cap_bias.n59 vco_inductor_v2_0/VSUBS 0.061f $ **FLOATING
C749 vco_varactors_0/cap_bias.n60 vco_inductor_v2_0/VSUBS 0.04263f $ **FLOATING
C750 vco_varactors_0/cap_bias.n61 vco_inductor_v2_0/VSUBS 0.08986f $ **FLOATING
C751 vco_varactors_0/cap_bias.n63 vco_inductor_v2_0/VSUBS 0.07111f $ **FLOATING
C752 vco_varactors_0/cap_bias.n64 vco_inductor_v2_0/VSUBS 0.17429f $ **FLOATING
C753 vco_varactors_0/cap_bias.n65 vco_inductor_v2_0/VSUBS 0.37354f $ **FLOATING
C754 vco_varactors_0/cap_bias.n67 vco_inductor_v2_0/VSUBS 0.07197f $ **FLOATING
C755 vco_varactors_0/cap_bias.t37 vco_inductor_v2_0/VSUBS 1.04297f $ **FLOATING
C756 vco_varactors_0/cap_bias.n68 vco_inductor_v2_0/VSUBS 0.175f $ **FLOATING
C757 vco_varactors_0/cap_bias.n69 vco_inductor_v2_0/VSUBS 0.06035f $ **FLOATING
C758 vco_varactors_0/cap_bias.n72 vco_inductor_v2_0/VSUBS 0.37354f $ **FLOATING
C759 vco_varactors_0/cap_bias.n73 vco_inductor_v2_0/VSUBS 0.17365f $ **FLOATING
C760 vco_varactors_0/cap_bias.n74 vco_inductor_v2_0/VSUBS 0.37354f $ **FLOATING
C761 vco_varactors_0/cap_bias.n76 vco_inductor_v2_0/VSUBS 0.07197f $ **FLOATING
C762 vco_varactors_0/cap_bias.t38 vco_inductor_v2_0/VSUBS 1.04297f $ **FLOATING
C763 vco_varactors_0/cap_bias.n77 vco_inductor_v2_0/VSUBS 0.175f $ **FLOATING
C764 vco_varactors_0/cap_bias.n78 vco_inductor_v2_0/VSUBS 0.06035f $ **FLOATING
C765 vco_varactors_0/cap_bias.n81 vco_inductor_v2_0/VSUBS 0.37354f $ **FLOATING
C766 vco_varactors_0/cap_bias.n82 vco_inductor_v2_0/VSUBS 0.17365f $ **FLOATING
C767 vco_varactors_0/cap_bias.n83 vco_inductor_v2_0/VSUBS 0.37354f $ **FLOATING
C768 vco_varactors_0/cap_bias.n85 vco_inductor_v2_0/VSUBS 0.07197f $ **FLOATING
C769 vco_varactors_0/cap_bias.t39 vco_inductor_v2_0/VSUBS 1.04297f $ **FLOATING
C770 vco_varactors_0/cap_bias.n86 vco_inductor_v2_0/VSUBS 0.175f $ **FLOATING
C771 vco_varactors_0/cap_bias.n87 vco_inductor_v2_0/VSUBS 0.06035f $ **FLOATING
C772 vco_varactors_0/cap_bias.n90 vco_inductor_v2_0/VSUBS 0.37354f $ **FLOATING
C773 vco_varactors_0/cap_bias.n91 vco_inductor_v2_0/VSUBS 0.17365f $ **FLOATING
C774 vco_varactors_0/cap_bias.n92 vco_inductor_v2_0/VSUBS 0.37354f $ **FLOATING
C775 vco_varactors_0/cap_bias.n94 vco_inductor_v2_0/VSUBS 0.07197f $ **FLOATING
C776 vco_varactors_0/cap_bias.t40 vco_inductor_v2_0/VSUBS 1.04297f $ **FLOATING
C777 vco_varactors_0/cap_bias.n95 vco_inductor_v2_0/VSUBS 0.175f $ **FLOATING
C778 vco_varactors_0/cap_bias.n96 vco_inductor_v2_0/VSUBS 0.06035f $ **FLOATING
C779 vco_varactors_0/cap_bias.n99 vco_inductor_v2_0/VSUBS 0.37354f $ **FLOATING
C780 vco_varactors_0/cap_bias.n100 vco_inductor_v2_0/VSUBS 0.17365f $ **FLOATING
C781 vco_varactors_0/cap_bias.n101 vco_inductor_v2_0/VSUBS 0.37354f $ **FLOATING
C782 vco_varactors_0/cap_bias.n103 vco_inductor_v2_0/VSUBS 0.061f $ **FLOATING
C783 vco_varactors_0/cap_bias.t5 vco_inductor_v2_0/VSUBS 1.11454f $ **FLOATING
C784 vco_varactors_0/cap_bias.t11 vco_inductor_v2_0/VSUBS 1.04297f $ **FLOATING
C785 vco_varactors_0/cap_bias.n104 vco_inductor_v2_0/VSUBS 1.29849f $ **FLOATING
C786 vco_varactors_0/cap_bias.t17 vco_inductor_v2_0/VSUBS 1.04297f $ **FLOATING
C787 vco_varactors_0/cap_bias.n105 vco_inductor_v2_0/VSUBS 0.7073f $ **FLOATING
C788 vco_varactors_0/cap_bias.t23 vco_inductor_v2_0/VSUBS 1.04297f $ **FLOATING
C789 vco_varactors_0/cap_bias.n106 vco_inductor_v2_0/VSUBS 0.7073f $ **FLOATING
C790 vco_varactors_0/cap_bias.t29 vco_inductor_v2_0/VSUBS 1.04297f $ **FLOATING
C791 vco_varactors_0/cap_bias.n107 vco_inductor_v2_0/VSUBS 0.7073f $ **FLOATING
C792 vco_varactors_0/cap_bias.t35 vco_inductor_v2_0/VSUBS 1.04297f $ **FLOATING
C793 vco_varactors_0/cap_bias.n108 vco_inductor_v2_0/VSUBS 0.50069f $ **FLOATING
C794 vco_varactors_0/cap_bias.n109 vco_inductor_v2_0/VSUBS 0.52005f $ **FLOATING
C795 vco_varactors_0/cap_bias.t41 vco_inductor_v2_0/VSUBS 1.04297f $ **FLOATING
C796 vco_varactors_0/cap_bias.n110 vco_inductor_v2_0/VSUBS 0.175f $ **FLOATING
C797 vco_varactors_0/cap_bias.n111 vco_inductor_v2_0/VSUBS 0.03779f $ **FLOATING
C798 vco_varactors_0/cap_bias.n112 vco_inductor_v2_0/VSUBS 0.37354f $ **FLOATING
C799 vco_varactors_0/cap_bias.n113 vco_inductor_v2_0/VSUBS 0.07107f $ **FLOATING
C800 vco_varactors_0/cap_bias.n114 vco_inductor_v2_0/VSUBS 0.00117f $ **FLOATING
C801 vco_varactors_0/cap_bias.n115 vco_inductor_v2_0/VSUBS 0.05987f $ **FLOATING
C802 vco_tune_r_0/cap_bias vco_inductor_v2_0/VSUBS 89.68935f
C803 TUNE vco_inductor_v2_0/VSUBS 0.33864f
.ends

* expanding   symbol:  vco_inductor_v2.sym # of pins=3
** sym_path: /foss/designs/AUS-NZ-integration/team_src/xschem/vco_inductor_v2.sym
.include $UPRJ_ROOT/team_src/xschem/vco_inductor_v2.subckt
.GLOBAL GND
.end
