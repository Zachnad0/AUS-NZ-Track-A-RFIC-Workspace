* NGSPICE file created from chip_top.ext - technology: gf180mcuD

.subckt ibias_gen_v1 IBIAS VGP VGN IB_DIV2 VDD VSS
X0 a_17124_n400# a_n1372_556# VSS VSS nfet_03v3 ad=1.04p pd=4.52u as=1.04p ps=4.52u w=4u l=2u
X1 a_1396_12024# IBIAS a_17124_n400# VSS nfet_03v3 ad=1.04p pd=4.52u as=1.04p ps=4.52u w=4u l=1u
X2 IB_DIV2 a_17692_12024# a_17124_4400# VDD pfet_03v3 ad=4.16p pd=16.52u as=4.16p ps=16.52u w=16u l=1u
X3 a_196_7624# a_196_7624# VDD VDD pfet_03v3 ad=4.16p pd=16.52u as=4.16p ps=16.52u w=16u l=2u
X4 VDD a_196_7624# a_196_7624# VDD pfet_03v3 ad=7.04p pd=32.88u as=4.16p ps=16.52u w=16u l=2u
X5 IBIAS IBIAS a_n1372_556# VSS nfet_03v3 ad=1.04p pd=4.52u as=1.04p ps=4.52u w=4u l=1u
X6 a_1396_12024# IBIAS a_17124_n400# VSS nfet_03v3 ad=1.04p pd=4.52u as=1.04p ps=4.52u w=4u l=1u
X7 VDD a_196_7624# a_17124_4400# VDD pfet_03v3 ad=4.16p pd=16.52u as=4.16p ps=16.52u w=16u l=2u
X8 a_17124_4400# a_196_7624# VDD VDD pfet_03v3 ad=4.16p pd=16.52u as=4.16p ps=16.52u w=16u l=2u
X9 a_17124_4400# a_196_7624# VDD VDD pfet_03v3 ad=4.16p pd=16.52u as=4.16p ps=16.52u w=16u l=2u
X10 a_17124_4400# a_196_7624# VDD VDD pfet_03v3 ad=4.16p pd=16.52u as=4.16p ps=16.52u w=16u l=2u
X11 IB_DIV2 a_17692_12024# a_17124_4400# VDD pfet_03v3 ad=4.16p pd=16.52u as=4.16p ps=16.52u w=16u l=1u
X12 a_196_7624# a_196_7624# VDD VDD pfet_03v3 ad=4.16p pd=16.52u as=4.16p ps=16.52u w=16u l=2u
X13 VDD a_196_7624# a_14044_4400# VDD pfet_03v3 ad=4.16p pd=16.52u as=4.16p ps=16.52u w=16u l=2u
X14 VGP IBIAS a_7436_n400# VSS nfet_03v3 ad=1.04p pd=4.52u as=1.76p ps=8.88u w=4u l=1u
X15 a_14044_4400# a_196_7624# VDD VDD pfet_03v3 ad=7.04p pd=32.88u as=4.16p ps=16.52u w=16u l=2u
X16 a_17124_n400# a_n1372_556# VSS VSS nfet_03v3 ad=1.04p pd=4.52u as=1.04p ps=4.52u w=4u l=2u
X17 VSS a_n1372_556# a_17124_n400# VSS nfet_03v3 ad=1.04p pd=4.52u as=1.04p ps=4.52u w=4u l=2u
X18 a_17124_n400# IBIAS a_1396_12024# VSS nfet_03v3 ad=1.04p pd=4.52u as=1.04p ps=4.52u w=4u l=1u
X19 IB_DIV2 a_17692_12024# a_17124_4400# VDD pfet_03v3 ad=4.16p pd=16.52u as=4.16p ps=16.52u w=16u l=1u
X20 a_17124_n400# a_n1372_556# VSS VSS nfet_03v3 ad=1.04p pd=4.52u as=1.04p ps=4.52u w=4u l=2u
X21 VSS a_n1372_556# a_17124_n400# VSS nfet_03v3 ad=1.04p pd=4.52u as=1.04p ps=4.52u w=4u l=2u
X22 IBIAS IBIAS a_n1372_556# VSS nfet_03v3 ad=1.04p pd=4.52u as=1.04p ps=4.52u w=4u l=1u
X23 VSS a_n1372_556# a_17124_n400# VSS nfet_03v3 ad=1.04p pd=4.52u as=1.04p ps=4.52u w=4u l=2u
X24 a_17124_n400# a_n1372_556# VSS VSS nfet_03v3 ad=1.04p pd=4.52u as=1.04p ps=4.52u w=4u l=2u
X25 VSS a_n1372_556# a_n1372_556# VSS nfet_03v3 ad=1.04p pd=4.52u as=1.04p ps=4.52u w=4u l=2u
X26 a_1396_12024# a_1396_12024# a_196_7624# VDD pfet_03v3 ad=4.16p pd=16.52u as=4.16p ps=16.52u w=16u l=1u
X27 VDD a_196_7624# a_17124_4400# VDD pfet_03v3 ad=4.16p pd=16.52u as=4.16p ps=16.52u w=16u l=2u
X28 a_n1372_556# IBIAS IBIAS VSS nfet_03v3 ad=1.04p pd=4.52u as=1.04p ps=4.52u w=4u l=1u
X29 a_17124_4400# a_17692_12024# IB_DIV2 VDD pfet_03v3 ad=4.16p pd=16.52u as=4.16p ps=16.52u w=16u l=1u
X30 VDD a_196_7624# a_17124_4400# VDD pfet_03v3 ad=4.16p pd=16.52u as=4.16p ps=16.52u w=16u l=2u
X31 VSS a_n1372_556# VSS VSS nfet_03v3 ad=1.76p pd=8.88u as=74.88p ps=0.34144m w=4u l=2u
X32 IB_DIV2 a_17692_12024# a_17124_4400# VDD pfet_03v3 ad=4.16p pd=16.52u as=4.16p ps=16.52u w=16u l=1u
X33 a_17124_4400# a_196_7624# VDD VDD pfet_03v3 ad=4.16p pd=16.52u as=4.16p ps=16.52u w=16u l=2u
X34 IBIAS IBIAS a_n1372_556# VSS nfet_03v3 ad=1.04p pd=4.52u as=1.04p ps=4.52u w=4u l=1u
X35 VGP IBIAS a_7436_n400# VSS nfet_03v3 ad=1.04p pd=4.52u as=1.04p ps=4.52u w=4u l=1u
X36 a_1396_12024# a_1396_12024# a_196_7624# VDD pfet_03v3 ad=4.16p pd=16.52u as=4.16p ps=16.52u w=16u l=1u
X37 a_17124_4400# a_196_7624# VDD VDD pfet_03v3 ad=4.16p pd=16.52u as=4.16p ps=16.52u w=16u l=2u
X38 VSS a_n1372_556# VSS VSS nfet_03v3 ad=1.76p pd=8.88u as=0 ps=0 w=4u l=2u
X39 a_17124_n400# IBIAS a_1396_12024# VSS nfet_03v3 ad=1.04p pd=4.52u as=1.04p ps=4.52u w=4u l=1u
X40 a_17124_4400# a_17692_12024# IB_DIV2 VDD pfet_03v3 ad=7.04p pd=32.88u as=4.16p ps=16.52u w=16u l=1u
X41 a_n1372_556# IBIAS IBIAS VSS nfet_03v3 ad=1.04p pd=4.52u as=1.04p ps=4.52u w=4u l=1u
X42 VSS a_n1372_556# a_17124_n400# VSS nfet_03v3 ad=1.04p pd=4.52u as=1.04p ps=4.52u w=4u l=2u
X43 IBIAS IBIAS a_n1372_556# VSS nfet_03v3 ad=1.04p pd=4.52u as=1.04p ps=4.52u w=4u l=1u
X44 a_n1372_556# IBIAS IBIAS VSS nfet_03v3 ad=1.04p pd=4.52u as=1.04p ps=4.52u w=4u l=1u
X45 a_196_7624# a_1396_12024# a_1396_12024# VDD pfet_03v3 ad=4.16p pd=16.52u as=4.16p ps=16.52u w=16u l=1u
X46 a_1396_12024# a_1396_12024# a_196_7624# VDD pfet_03v3 ad=4.16p pd=16.52u as=4.16p ps=16.52u w=16u l=1u
X47 a_17124_n400# a_n1372_556# VSS VSS nfet_03v3 ad=1.04p pd=4.52u as=1.04p ps=4.52u w=4u l=2u
X48 VSS a_n1372_556# a_17124_n400# VSS nfet_03v3 ad=1.04p pd=4.52u as=1.04p ps=4.52u w=4u l=2u
X49 a_17124_n400# a_n1372_556# VSS VSS nfet_03v3 ad=1.04p pd=4.52u as=1.04p ps=4.52u w=4u l=2u
X50 VSS a_n1372_556# a_17124_n400# VSS nfet_03v3 ad=1.04p pd=4.52u as=1.04p ps=4.52u w=4u l=2u
X51 VSS a_n1372_556# a_n1372_556# VSS nfet_03v3 ad=1.04p pd=4.52u as=1.04p ps=4.52u w=4u l=2u
X52 a_n1372_556# a_n1372_556# VSS VSS nfet_03v3 ad=1.04p pd=4.52u as=1.04p ps=4.52u w=4u l=2u
X53 a_17124_n400# a_n1372_556# VSS VSS nfet_03v3 ad=1.04p pd=4.52u as=1.04p ps=4.52u w=4u l=2u
X54 VSS a_n1372_556# a_n1372_556# VSS nfet_03v3 ad=1.04p pd=4.52u as=1.04p ps=4.52u w=4u l=2u
X55 a_17124_n400# IBIAS a_1396_12024# VSS nfet_03v3 ad=1.04p pd=4.52u as=1.04p ps=4.52u w=4u l=1u
X56 VDD a_196_7624# a_17124_4400# VDD pfet_03v3 ad=4.16p pd=16.52u as=4.16p ps=16.52u w=16u l=2u
X57 IBIAS IBIAS a_n1372_556# VSS nfet_03v3 ad=1.04p pd=4.52u as=1.04p ps=4.52u w=4u l=1u
X58 a_1396_12024# a_1396_12024# a_196_7624# VDD pfet_03v3 ad=4.16p pd=16.52u as=4.16p ps=16.52u w=16u l=1u
X59 VDD a_196_7624# a_17124_4400# VDD pfet_03v3 ad=7.04p pd=32.88u as=4.16p ps=16.52u w=16u l=2u
X60 VDD a_196_7624# a_17124_4400# VDD pfet_03v3 ad=4.16p pd=16.52u as=4.16p ps=16.52u w=16u l=2u
X61 a_1396_12024# IBIAS a_17124_n400# VSS nfet_03v3 ad=1.04p pd=4.52u as=1.04p ps=4.52u w=4u l=1u
X62 VDD a_196_7624# a_196_7624# VDD pfet_03v3 ad=4.16p pd=16.52u as=4.16p ps=16.52u w=16u l=2u
X63 VDD a_196_7624# a_17124_4400# VDD pfet_03v3 ad=4.16p pd=16.52u as=4.16p ps=16.52u w=16u l=2u
X64 a_n1372_556# IBIAS IBIAS VSS nfet_03v3 ad=1.04p pd=4.52u as=1.04p ps=4.52u w=4u l=1u
X65 VSS a_n1372_556# a_17124_n400# VSS nfet_03v3 ad=1.76p pd=8.88u as=1.04p ps=4.52u w=4u l=2u
X66 a_17124_4400# a_17692_12024# IB_DIV2 VDD pfet_03v3 ad=4.16p pd=16.52u as=4.16p ps=16.52u w=16u l=1u
X67 a_1396_12024# IBIAS a_17124_n400# VSS nfet_03v3 ad=1.04p pd=4.52u as=1.04p ps=4.52u w=4u l=1u
X68 VDD a_196_7624# VDD VDD pfet_03v3 ad=4.16p pd=16.52u as=0.31616n ps=1.31952m w=16u l=2u
X69 VSS a_n1372_556# a_17124_n400# VSS nfet_03v3 ad=1.04p pd=4.52u as=1.04p ps=4.52u w=4u l=2u
X70 a_1396_12024# a_1396_12024# a_196_7624# VDD pfet_03v3 ad=4.16p pd=16.52u as=7.04p ps=32.88u w=16u l=1u
X71 VSS a_n1372_556# a_17124_n400# VSS nfet_03v3 ad=1.04p pd=4.52u as=1.04p ps=4.52u w=4u l=2u
X72 a_1396_12024# IBIAS a_17124_n400# VSS nfet_03v3 ad=1.04p pd=4.52u as=1.04p ps=4.52u w=4u l=1u
X73 a_1396_12024# IBIAS a_17124_n400# VSS nfet_03v3 ad=1.04p pd=4.52u as=1.04p ps=4.52u w=4u l=1u
X74 a_17124_n400# IBIAS a_1396_12024# VSS nfet_03v3 ad=1.04p pd=4.52u as=1.04p ps=4.52u w=4u l=1u
X75 a_17124_4400# a_196_7624# VDD VDD pfet_03v3 ad=4.16p pd=16.52u as=4.16p ps=16.52u w=16u l=2u
X76 a_n1372_556# a_n1372_556# VSS VSS nfet_03v3 ad=1.04p pd=4.52u as=1.04p ps=4.52u w=4u l=2u
X77 VGN a_1396_12024# a_14044_4400# VDD pfet_03v3 ad=4.16p pd=16.52u as=4.16p ps=16.52u w=16u l=1u
X78 VDD a_196_7624# a_17124_4400# VDD pfet_03v3 ad=4.16p pd=16.52u as=4.16p ps=16.52u w=16u l=2u
X79 a_n1372_556# IBIAS IBIAS VSS nfet_03v3 ad=1.04p pd=4.52u as=1.04p ps=4.52u w=4u l=1u
X80 VSS a_n1372_556# a_n1372_556# VSS nfet_03v3 ad=1.04p pd=4.52u as=1.04p ps=4.52u w=4u l=2u
X81 a_1396_12024# a_1396_12024# a_196_7624# VDD pfet_03v3 ad=4.16p pd=16.52u as=4.16p ps=16.52u w=16u l=1u
X82 a_196_7624# a_1396_12024# a_1396_12024# VDD pfet_03v3 ad=7.04p pd=32.88u as=4.16p ps=16.52u w=16u l=1u
X83 a_17124_4400# a_196_7624# VDD VDD pfet_03v3 ad=4.16p pd=16.52u as=7.04p ps=32.88u w=16u l=2u
X84 VSS a_n1372_556# VSS VSS nfet_03v3 ad=1.04p pd=4.52u as=0 ps=0 w=4u l=2u
X85 a_33292_7624# a_17692_12024# a_17692_12024# VDD pfet_03v3 ad=7.04p pd=32.88u as=4.16p ps=16.52u w=16u l=1u
X86 VDD a_196_7624# a_17124_4400# VDD pfet_03v3 ad=4.16p pd=16.52u as=4.16p ps=16.52u w=16u l=2u
X87 a_196_7624# a_1396_12024# a_1396_12024# VDD pfet_03v3 ad=4.16p pd=16.52u as=4.16p ps=16.52u w=16u l=1u
X88 a_17124_4400# a_17692_12024# IB_DIV2 VDD pfet_03v3 ad=4.16p pd=16.52u as=4.16p ps=16.52u w=16u l=1u
X89 IB_DIV2 a_17692_12024# a_17124_4400# VDD pfet_03v3 ad=4.16p pd=16.52u as=4.16p ps=16.52u w=16u l=1u
X90 a_196_7624# a_196_7624# VDD VDD pfet_03v3 ad=4.16p pd=16.52u as=4.16p ps=16.52u w=16u l=2u
X91 VDD a_196_7624# a_17124_4400# VDD pfet_03v3 ad=4.16p pd=16.52u as=4.16p ps=16.52u w=16u l=2u
X92 a_17124_4400# a_17692_12024# IB_DIV2 VDD pfet_03v3 ad=4.16p pd=16.52u as=4.16p ps=16.52u w=16u l=1u
X93 IB_DIV2 a_17692_12024# a_17124_4400# VDD pfet_03v3 ad=4.16p pd=16.52u as=7.04p ps=32.88u w=16u l=1u
X94 VDD a_196_7624# a_196_7624# VDD pfet_03v3 ad=4.16p pd=16.52u as=4.16p ps=16.52u w=16u l=2u
X95 a_17124_n400# IBIAS a_1396_12024# VSS nfet_03v3 ad=1.04p pd=4.52u as=1.04p ps=4.52u w=4u l=1u
X96 IBIAS IBIAS a_n1372_556# VSS nfet_03v3 ad=1.04p pd=4.52u as=1.76p ps=8.88u w=4u l=1u
X97 a_7436_n400# IBIAS VGP VSS nfet_03v3 ad=1.04p pd=4.52u as=1.04p ps=4.52u w=4u l=1u
X98 a_1396_12024# a_1396_12024# a_196_7624# VDD pfet_03v3 ad=4.16p pd=16.52u as=4.16p ps=16.52u w=16u l=1u
X99 VDD a_196_7624# a_196_7624# VDD pfet_03v3 ad=4.16p pd=16.52u as=4.16p ps=16.52u w=16u l=2u
X100 VSS a_n1372_556# a_17692_12024# VSS nfet_03v3 ad=1.76p pd=8.88u as=1.04p ps=4.52u w=4u l=2u
X101 a_17124_4400# a_17692_12024# IB_DIV2 VDD pfet_03v3 ad=4.16p pd=16.52u as=4.16p ps=16.52u w=16u l=1u
X102 VSS a_n1372_556# a_n1372_556# VSS nfet_03v3 ad=1.04p pd=4.52u as=1.04p ps=4.52u w=4u l=2u
X103 a_1396_12024# IBIAS a_17124_n400# VSS nfet_03v3 ad=1.04p pd=4.52u as=1.04p ps=4.52u w=4u l=1u
X104 VGN a_1396_12024# a_14044_4400# VDD pfet_03v3 ad=7.04p pd=32.88u as=4.16p ps=16.52u w=16u l=1u
X105 a_n1372_556# IBIAS IBIAS VSS nfet_03v3 ad=1.04p pd=4.52u as=1.04p ps=4.52u w=4u l=1u
X106 VDD a_196_7624# VDD VDD pfet_03v3 ad=4.16p pd=16.52u as=0 ps=0 w=16u l=2u
X107 a_n1372_556# IBIAS IBIAS VSS nfet_03v3 ad=1.04p pd=4.52u as=1.04p ps=4.52u w=4u l=1u
X108 VSS a_n1372_556# a_17124_n400# VSS nfet_03v3 ad=1.04p pd=4.52u as=1.04p ps=4.52u w=4u l=2u
X109 a_n1372_556# a_n1372_556# VSS VSS nfet_03v3 ad=1.04p pd=4.52u as=1.04p ps=4.52u w=4u l=2u
X110 a_17124_4400# a_196_7624# VDD VDD pfet_03v3 ad=4.16p pd=16.52u as=4.16p ps=16.52u w=16u l=2u
X111 VSS a_n1372_556# a_n1372_556# VSS nfet_03v3 ad=1.76p pd=8.88u as=1.04p ps=4.52u w=4u l=2u
X112 a_n1372_556# a_n1372_556# VSS VSS nfet_03v3 ad=1.04p pd=4.52u as=1.04p ps=4.52u w=4u l=2u
X113 a_n1372_556# a_n1372_556# VSS VSS nfet_03v3 ad=1.04p pd=4.52u as=1.76p ps=8.88u w=4u l=2u
X114 VDD a_196_7624# a_17124_4400# VDD pfet_03v3 ad=7.04p pd=32.88u as=4.16p ps=16.52u w=16u l=2u
X115 a_17124_4400# a_196_7624# VDD VDD pfet_03v3 ad=4.16p pd=16.52u as=4.16p ps=16.52u w=16u l=2u
X116 VDD a_196_7624# a_17124_4400# VDD pfet_03v3 ad=4.16p pd=16.52u as=4.16p ps=16.52u w=16u l=2u
X117 VSS a_n1372_556# a_n1372_556# VSS nfet_03v3 ad=1.04p pd=4.52u as=1.04p ps=4.52u w=4u l=2u
X118 IB_DIV2 a_17692_12024# a_17124_4400# VDD pfet_03v3 ad=4.16p pd=16.52u as=4.16p ps=16.52u w=16u l=1u
X119 VSS a_n1372_556# VSS VSS nfet_03v3 ad=1.04p pd=4.52u as=0 ps=0 w=4u l=2u
X120 a_196_7624# a_1396_12024# a_1396_12024# VDD pfet_03v3 ad=4.16p pd=16.52u as=4.16p ps=16.52u w=16u l=1u
X121 a_196_7624# a_196_7624# VDD VDD pfet_03v3 ad=4.16p pd=16.52u as=4.16p ps=16.52u w=16u l=2u
X122 VDD a_196_7624# a_196_7624# VDD pfet_03v3 ad=4.16p pd=16.52u as=4.16p ps=16.52u w=16u l=2u
X123 a_17124_n400# IBIAS a_1396_12024# VSS nfet_03v3 ad=1.04p pd=4.52u as=1.04p ps=4.52u w=4u l=1u
X124 VSS a_n1372_556# a_7436_n400# VSS nfet_03v3 ad=1.04p pd=4.52u as=1.04p ps=4.52u w=4u l=2u
X125 IBIAS IBIAS a_n1372_556# VSS nfet_03v3 ad=1.04p pd=4.52u as=1.04p ps=4.52u w=4u l=1u
X126 VSS a_n1372_556# a_n1372_556# VSS nfet_03v3 ad=1.04p pd=4.52u as=1.04p ps=4.52u w=4u l=2u
X127 a_n1372_556# a_n1372_556# VSS VSS nfet_03v3 ad=1.04p pd=4.52u as=1.76p ps=8.88u w=4u l=2u
X128 a_17124_n400# IBIAS a_1396_12024# VSS nfet_03v3 ad=1.04p pd=4.52u as=1.04p ps=4.52u w=4u l=1u
X129 a_17124_4400# a_17692_12024# IB_DIV2 VDD pfet_03v3 ad=4.16p pd=16.52u as=4.16p ps=16.52u w=16u l=1u
X130 VDD a_196_7624# VDD VDD pfet_03v3 ad=4.16p pd=16.52u as=0 ps=0 w=16u l=2u
X131 VSS a_n1372_556# a_n1372_556# VSS nfet_03v3 ad=1.04p pd=4.52u as=1.04p ps=4.52u w=4u l=2u
X132 VDD a_196_7624# VDD VDD pfet_03v3 ad=7.04p pd=32.88u as=0 ps=0 w=16u l=2u
X133 a_1396_12024# IBIAS a_17124_n400# VSS nfet_03v3 ad=1.04p pd=4.52u as=1.76p ps=8.88u w=4u l=1u
X134 a_7436_n400# IBIAS VGP VSS nfet_03v3 ad=1.04p pd=4.52u as=1.04p ps=4.52u w=4u l=1u
X135 a_n1372_556# a_n1372_556# VSS VSS nfet_03v3 ad=1.04p pd=4.52u as=1.04p ps=4.52u w=4u l=2u
X136 VGN a_1396_12024# a_14044_4400# VDD pfet_03v3 ad=4.16p pd=16.52u as=7.04p ps=32.88u w=16u l=1u
X137 a_17124_4400# a_196_7624# VDD VDD pfet_03v3 ad=4.16p pd=16.52u as=4.16p ps=16.52u w=16u l=2u
X138 a_17124_4400# a_17692_12024# IB_DIV2 VDD pfet_03v3 ad=4.16p pd=16.52u as=4.16p ps=16.52u w=16u l=1u
X139 a_n1372_556# IBIAS IBIAS VSS nfet_03v3 ad=1.04p pd=4.52u as=1.04p ps=4.52u w=4u l=1u
X140 a_196_7624# a_1396_12024# a_1396_12024# VDD pfet_03v3 ad=4.16p pd=16.52u as=4.16p ps=16.52u w=16u l=1u
X141 a_17124_n400# IBIAS a_1396_12024# VSS nfet_03v3 ad=1.76p pd=8.88u as=1.04p ps=4.52u w=4u l=1u
X142 a_1396_12024# a_1396_12024# a_196_7624# VDD pfet_03v3 ad=4.16p pd=16.52u as=4.16p ps=16.52u w=16u l=1u
X143 a_1396_12024# a_1396_12024# a_196_7624# VDD pfet_03v3 ad=4.16p pd=16.52u as=4.16p ps=16.52u w=16u l=1u
X144 a_196_7624# a_1396_12024# a_1396_12024# VDD pfet_03v3 ad=4.16p pd=16.52u as=4.16p ps=16.52u w=16u l=1u
X145 a_196_7624# a_196_7624# VDD VDD pfet_03v3 ad=4.16p pd=16.52u as=4.16p ps=16.52u w=16u l=2u
X146 IBIAS IBIAS a_n1372_556# VSS nfet_03v3 ad=1.04p pd=4.52u as=1.04p ps=4.52u w=4u l=1u
X147 IB_DIV2 a_17692_12024# a_17124_4400# VDD pfet_03v3 ad=4.16p pd=16.52u as=4.16p ps=16.52u w=16u l=1u
X148 a_196_7624# a_196_7624# VDD VDD pfet_03v3 ad=4.16p pd=16.52u as=7.04p ps=32.88u w=16u l=2u
X149 a_196_7624# a_196_7624# VDD VDD pfet_03v3 ad=4.16p pd=16.52u as=4.16p ps=16.52u w=16u l=2u
X150 a_33292_7624# a_33292_7624# VDD VDD pfet_03v3 ad=4.16p pd=16.52u as=7.04p ps=32.88u w=16u l=2u
X151 VDD a_196_7624# a_196_7624# VDD pfet_03v3 ad=7.04p pd=32.88u as=4.16p ps=16.52u w=16u l=2u
X152 a_7436_n400# a_n1372_556# VSS VSS nfet_03v3 ad=1.04p pd=4.52u as=1.76p ps=8.88u w=4u l=2u
X153 a_17124_n400# IBIAS a_1396_12024# VSS nfet_03v3 ad=1.04p pd=4.52u as=1.04p ps=4.52u w=4u l=1u
X154 IB_DIV2 a_17692_12024# a_17124_4400# VDD pfet_03v3 ad=4.16p pd=16.52u as=4.16p ps=16.52u w=16u l=1u
X155 a_17124_4400# a_17692_12024# IB_DIV2 VDD pfet_03v3 ad=4.16p pd=16.52u as=4.16p ps=16.52u w=16u l=1u
X156 a_17692_12024# a_n1372_556# VSS VSS nfet_03v3 ad=1.04p pd=4.52u as=1.76p ps=8.88u w=4u l=2u
X157 VDD a_196_7624# a_196_7624# VDD pfet_03v3 ad=4.16p pd=16.52u as=4.16p ps=16.52u w=16u l=2u
X158 IBIAS IBIAS a_n1372_556# VSS nfet_03v3 ad=1.04p pd=4.52u as=1.04p ps=4.52u w=4u l=1u
X159 a_n1372_556# a_n1372_556# VSS VSS nfet_03v3 ad=1.04p pd=4.52u as=1.04p ps=4.52u w=4u l=2u
X160 a_n1372_556# IBIAS IBIAS VSS nfet_03v3 ad=1.04p pd=4.52u as=1.04p ps=4.52u w=4u l=1u
X161 VSS a_n1372_556# a_n1372_556# VSS nfet_03v3 ad=1.04p pd=4.52u as=1.04p ps=4.52u w=4u l=2u
X162 VSS a_n1372_556# a_7436_n400# VSS nfet_03v3 ad=1.04p pd=4.52u as=1.04p ps=4.52u w=4u l=2u
X163 VDD a_196_7624# VDD VDD pfet_03v3 ad=4.16p pd=16.52u as=0 ps=0 w=16u l=2u
X164 a_17124_n400# IBIAS a_1396_12024# VSS nfet_03v3 ad=1.04p pd=4.52u as=1.04p ps=4.52u w=4u l=1u
X165 IBIAS IBIAS a_n1372_556# VSS nfet_03v3 ad=1.04p pd=4.52u as=1.04p ps=4.52u w=4u l=1u
X166 VDD a_196_7624# a_196_7624# VDD pfet_03v3 ad=4.16p pd=16.52u as=4.16p ps=16.52u w=16u l=2u
X167 a_17124_4400# a_196_7624# VDD VDD pfet_03v3 ad=4.16p pd=16.52u as=4.16p ps=16.52u w=16u l=2u
X168 a_1396_12024# a_1396_12024# a_196_7624# VDD pfet_03v3 ad=4.16p pd=16.52u as=4.16p ps=16.52u w=16u l=1u
X169 a_196_7624# a_1396_12024# a_1396_12024# VDD pfet_03v3 ad=7.04p pd=32.88u as=4.16p ps=16.52u w=16u l=1u
X170 VDD a_33292_7624# a_33292_7624# VDD pfet_03v3 ad=7.04p pd=32.88u as=4.16p ps=16.52u w=16u l=2u
X171 a_17124_4400# a_17692_12024# IB_DIV2 VDD pfet_03v3 ad=4.16p pd=16.52u as=4.16p ps=16.52u w=16u l=1u
X172 a_17124_n400# a_n1372_556# VSS VSS nfet_03v3 ad=1.04p pd=4.52u as=1.76p ps=8.88u w=4u l=2u
X173 a_1396_12024# IBIAS a_17124_n400# VSS nfet_03v3 ad=1.04p pd=4.52u as=1.04p ps=4.52u w=4u l=1u
X174 a_196_7624# a_1396_12024# a_1396_12024# VDD pfet_03v3 ad=4.16p pd=16.52u as=4.16p ps=16.52u w=16u l=1u
X175 a_196_7624# a_196_7624# VDD VDD pfet_03v3 ad=4.16p pd=16.52u as=4.16p ps=16.52u w=16u l=2u
X176 VDD a_196_7624# a_196_7624# VDD pfet_03v3 ad=4.16p pd=16.52u as=4.16p ps=16.52u w=16u l=2u
X177 a_n1372_556# IBIAS IBIAS VSS nfet_03v3 ad=1.04p pd=4.52u as=1.04p ps=4.52u w=4u l=1u
X178 a_n1372_556# a_n1372_556# VSS VSS nfet_03v3 ad=1.04p pd=4.52u as=1.04p ps=4.52u w=4u l=2u
X179 a_7436_n400# a_n1372_556# VSS VSS nfet_03v3 ad=1.04p pd=4.52u as=1.04p ps=4.52u w=4u l=2u
X180 a_17692_12024# a_17692_12024# a_33292_7624# VDD pfet_03v3 ad=4.16p pd=16.52u as=7.04p ps=32.88u w=16u l=1u
X181 VSS a_n1372_556# a_n1372_556# VSS nfet_03v3 ad=1.04p pd=4.52u as=1.04p ps=4.52u w=4u l=2u
X182 a_n1372_556# a_n1372_556# VSS VSS nfet_03v3 ad=1.04p pd=4.52u as=1.04p ps=4.52u w=4u l=2u
X183 IBIAS IBIAS a_n1372_556# VSS nfet_03v3 ad=1.04p pd=4.52u as=1.04p ps=4.52u w=4u l=1u
X184 VDD a_196_7624# VDD VDD pfet_03v3 ad=4.16p pd=16.52u as=0 ps=0 w=16u l=2u
X185 a_1396_12024# IBIAS a_17124_n400# VSS nfet_03v3 ad=1.04p pd=4.52u as=1.04p ps=4.52u w=4u l=1u
X186 a_17124_n400# IBIAS a_1396_12024# VSS nfet_03v3 ad=1.04p pd=4.52u as=1.04p ps=4.52u w=4u l=1u
X187 a_17124_n400# IBIAS a_1396_12024# VSS nfet_03v3 ad=1.04p pd=4.52u as=1.04p ps=4.52u w=4u l=1u
X188 a_196_7624# a_1396_12024# a_1396_12024# VDD pfet_03v3 ad=4.16p pd=16.52u as=4.16p ps=16.52u w=16u l=1u
X189 a_196_7624# a_196_7624# VDD VDD pfet_03v3 ad=4.16p pd=16.52u as=7.04p ps=32.88u w=16u l=2u
X190 VDD a_196_7624# a_196_7624# VDD pfet_03v3 ad=4.16p pd=16.52u as=4.16p ps=16.52u w=16u l=2u
X191 a_14044_4400# a_1396_12024# VGN VDD pfet_03v3 ad=4.16p pd=16.52u as=4.16p ps=16.52u w=16u l=1u
X192 a_17124_4400# a_17692_12024# IB_DIV2 VDD pfet_03v3 ad=4.16p pd=16.52u as=4.16p ps=16.52u w=16u l=1u
X193 IB_DIV2 a_17692_12024# a_17124_4400# VDD pfet_03v3 ad=4.16p pd=16.52u as=4.16p ps=16.52u w=16u l=1u
X194 VDD a_196_7624# a_196_7624# VDD pfet_03v3 ad=4.16p pd=16.52u as=4.16p ps=16.52u w=16u l=2u
X195 a_14044_4400# a_196_7624# VDD VDD pfet_03v3 ad=4.16p pd=16.52u as=7.04p ps=32.88u w=16u l=2u
X196 a_1396_12024# IBIAS a_17124_n400# VSS nfet_03v3 ad=1.04p pd=4.52u as=1.04p ps=4.52u w=4u l=1u
X197 a_1396_12024# a_1396_12024# a_196_7624# VDD pfet_03v3 ad=4.16p pd=16.52u as=4.16p ps=16.52u w=16u l=1u
X198 VSS a_n1372_556# a_17124_n400# VSS nfet_03v3 ad=1.04p pd=4.52u as=1.04p ps=4.52u w=4u l=2u
X199 a_17124_n400# a_n1372_556# VSS VSS nfet_03v3 ad=1.04p pd=4.52u as=1.04p ps=4.52u w=4u l=2u
X200 a_196_7624# a_196_7624# VDD VDD pfet_03v3 ad=4.16p pd=16.52u as=4.16p ps=16.52u w=16u l=2u
X201 a_17124_n400# a_n1372_556# VSS VSS nfet_03v3 ad=1.04p pd=4.52u as=1.04p ps=4.52u w=4u l=2u
X202 a_1396_12024# a_1396_12024# a_196_7624# VDD pfet_03v3 ad=4.16p pd=16.52u as=7.04p ps=32.88u w=16u l=1u
X203 a_196_7624# a_1396_12024# a_1396_12024# VDD pfet_03v3 ad=4.16p pd=16.52u as=4.16p ps=16.52u w=16u l=1u
X204 a_17124_n400# a_n1372_556# VSS VSS nfet_03v3 ad=1.04p pd=4.52u as=1.04p ps=4.52u w=4u l=2u
X205 VDD a_196_7624# a_196_7624# VDD pfet_03v3 ad=4.16p pd=16.52u as=4.16p ps=16.52u w=16u l=2u
X206 a_n1372_556# IBIAS IBIAS VSS nfet_03v3 ad=1.76p pd=8.88u as=1.04p ps=4.52u w=4u l=1u
X207 a_n1372_556# a_n1372_556# VSS VSS nfet_03v3 ad=1.04p pd=4.52u as=1.04p ps=4.52u w=4u l=2u
X208 a_7436_n400# a_n1372_556# VSS VSS nfet_03v3 ad=1.76p pd=8.88u as=1.04p ps=4.52u w=4u l=2u
X209 a_1396_12024# IBIAS a_17124_n400# VSS nfet_03v3 ad=1.04p pd=4.52u as=1.04p ps=4.52u w=4u l=1u
X210 a_n1372_556# a_n1372_556# VSS VSS nfet_03v3 ad=1.04p pd=4.52u as=1.04p ps=4.52u w=4u l=2u
X211 a_n1372_556# IBIAS IBIAS VSS nfet_03v3 ad=1.04p pd=4.52u as=1.04p ps=4.52u w=4u l=1u
X212 VSS a_n1372_556# a_n1372_556# VSS nfet_03v3 ad=1.76p pd=8.88u as=1.04p ps=4.52u w=4u l=2u
X213 a_196_7624# a_1396_12024# a_1396_12024# VDD pfet_03v3 ad=4.16p pd=16.52u as=4.16p ps=16.52u w=16u l=1u
X214 VGP IBIAS a_7436_n400# VSS nfet_03v3 ad=1.76p pd=8.88u as=1.04p ps=4.52u w=4u l=1u
X215 a_17124_4400# a_196_7624# VDD VDD pfet_03v3 ad=4.16p pd=16.52u as=7.04p ps=32.88u w=16u l=2u
X216 a_14044_4400# a_1396_12024# VGN VDD pfet_03v3 ad=4.16p pd=16.52u as=4.16p ps=16.52u w=16u l=1u
X217 IB_DIV2 a_17692_12024# a_17124_4400# VDD pfet_03v3 ad=4.16p pd=16.52u as=4.16p ps=16.52u w=16u l=1u
X218 IBIAS IBIAS a_n1372_556# VSS nfet_03v3 ad=1.04p pd=4.52u as=1.04p ps=4.52u w=4u l=1u
X219 a_196_7624# a_196_7624# VDD VDD pfet_03v3 ad=4.16p pd=16.52u as=4.16p ps=16.52u w=16u l=2u
X220 VDD a_196_7624# a_14044_4400# VDD pfet_03v3 ad=4.16p pd=16.52u as=4.16p ps=16.52u w=16u l=2u
X221 a_196_7624# a_1396_12024# a_1396_12024# VDD pfet_03v3 ad=4.16p pd=16.52u as=4.16p ps=16.52u w=16u l=1u
X222 a_14044_4400# a_196_7624# VDD VDD pfet_03v3 ad=4.16p pd=16.52u as=4.16p ps=16.52u w=16u l=2u
X223 IB_DIV2 a_17692_12024# a_17124_4400# VDD pfet_03v3 ad=4.16p pd=16.52u as=7.04p ps=32.88u w=16u l=1u
X224 a_17124_4400# a_17692_12024# IB_DIV2 VDD pfet_03v3 ad=7.04p pd=32.88u as=4.16p ps=16.52u w=16u l=1u
X225 VSS a_n1372_556# a_17124_n400# VSS nfet_03v3 ad=1.04p pd=4.52u as=1.04p ps=4.52u w=4u l=2u
X226 a_196_7624# a_196_7624# VDD VDD pfet_03v3 ad=4.16p pd=16.52u as=4.16p ps=16.52u w=16u l=2u
X227 a_17124_n400# a_n1372_556# VSS VSS nfet_03v3 ad=1.04p pd=4.52u as=1.04p ps=4.52u w=4u l=2u
.ends

.subckt gf180mcu_fd_sc_mcu7t5v0__fillcap_8 VDD VSS VNW VPW
X0 VDD a_572_375# a_484_472# VNW pfet_05v0 ad=0.5368p pd=3.32u as=0.5368p ps=3.32u w=1.22u l=1u
X1 a_572_375# a_484_472# VSS VPW nfet_05v0 ad=0.3608p pd=2.52u as=0.3608p ps=2.52u w=0.82u l=1u
X2 a_124_375# a_36_472# VSS VPW nfet_05v0 ad=0.3608p pd=2.52u as=0.3608p ps=2.52u w=0.82u l=1u
X3 VDD a_124_375# a_36_472# VNW pfet_05v0 ad=0.5368p pd=3.32u as=0.5368p ps=3.32u w=1.22u l=1u
.ends

.subckt gf180mcu_fd_sc_mcu7t5v0__fillcap_32 VDD VSS VNW VPW
X0 VDD a_572_375# a_484_472# VNW pfet_05v0 ad=0.5368p pd=3.32u as=0.5368p ps=3.32u w=1.22u l=1u
X1 VDD a_2364_375# a_2276_472# VNW pfet_05v0 ad=0.5368p pd=3.32u as=0.5368p ps=3.32u w=1.22u l=1u
X2 a_572_375# a_484_472# VSS VPW nfet_05v0 ad=0.3608p pd=2.52u as=0.3608p ps=2.52u w=0.82u l=1u
X3 VDD a_1916_375# a_1828_472# VNW pfet_05v0 ad=0.5368p pd=3.32u as=0.5368p ps=3.32u w=1.22u l=1u
X4 a_124_375# a_36_472# VSS VPW nfet_05v0 ad=0.3608p pd=2.52u as=0.3608p ps=2.52u w=0.82u l=1u
X5 a_1916_375# a_1828_472# VSS VPW nfet_05v0 ad=0.3608p pd=2.52u as=0.3608p ps=2.52u w=0.82u l=1u
X6 a_1468_375# a_1380_472# VSS VPW nfet_05v0 ad=0.3608p pd=2.52u as=0.3608p ps=2.52u w=0.82u l=1u
X7 a_2812_375# a_2724_472# VSS VPW nfet_05v0 ad=0.3608p pd=2.52u as=0.3608p ps=2.52u w=0.82u l=1u
X8 VDD a_3260_375# a_3172_472# VNW pfet_05v0 ad=0.5368p pd=3.32u as=0.5368p ps=3.32u w=1.22u l=1u
X9 a_2364_375# a_2276_472# VSS VPW nfet_05v0 ad=0.3608p pd=2.52u as=0.3608p ps=2.52u w=0.82u l=1u
X10 VDD a_2812_375# a_2724_472# VNW pfet_05v0 ad=0.5368p pd=3.32u as=0.5368p ps=3.32u w=1.22u l=1u
X11 a_3260_375# a_3172_472# VSS VPW nfet_05v0 ad=0.3608p pd=2.52u as=0.3608p ps=2.52u w=0.82u l=1u
X12 VDD a_1020_375# a_932_472# VNW pfet_05v0 ad=0.5368p pd=3.32u as=0.5368p ps=3.32u w=1.22u l=1u
X13 VDD a_1468_375# a_1380_472# VNW pfet_05v0 ad=0.5368p pd=3.32u as=0.5368p ps=3.32u w=1.22u l=1u
X14 VDD a_124_375# a_36_472# VNW pfet_05v0 ad=0.5368p pd=3.32u as=0.5368p ps=3.32u w=1.22u l=1u
X15 a_1020_375# a_932_472# VSS VPW nfet_05v0 ad=0.3608p pd=2.52u as=0.3608p ps=2.52u w=0.82u l=1u
.ends

.subckt gf180mcu_fd_sc_mcu7t5v0__fillcap_16 VDD VSS VNW VPW
X0 VDD a_572_375# a_484_472# VNW pfet_05v0 ad=0.5368p pd=3.32u as=0.5368p ps=3.32u w=1.22u l=1u
X1 a_572_375# a_484_472# VSS VPW nfet_05v0 ad=0.3608p pd=2.52u as=0.3608p ps=2.52u w=0.82u l=1u
X2 a_124_375# a_36_472# VSS VPW nfet_05v0 ad=0.3608p pd=2.52u as=0.3608p ps=2.52u w=0.82u l=1u
X3 a_1468_375# a_1380_472# VSS VPW nfet_05v0 ad=0.3608p pd=2.52u as=0.3608p ps=2.52u w=0.82u l=1u
X4 VDD a_1020_375# a_932_472# VNW pfet_05v0 ad=0.5368p pd=3.32u as=0.5368p ps=3.32u w=1.22u l=1u
X5 VDD a_1468_375# a_1380_472# VNW pfet_05v0 ad=0.5368p pd=3.32u as=0.5368p ps=3.32u w=1.22u l=1u
X6 VDD a_124_375# a_36_472# VNW pfet_05v0 ad=0.5368p pd=3.32u as=0.5368p ps=3.32u w=1.22u l=1u
X7 a_1020_375# a_932_472# VSS VPW nfet_05v0 ad=0.3608p pd=2.52u as=0.3608p ps=2.52u w=0.82u l=1u
.ends

.subckt gf180mcu_fd_sc_mcu7t5v0__fillcap_4 VDD VSS VNW VPW
X0 a_124_375# a_36_472# VSS VPW nfet_05v0 ad=0.3608p pd=2.52u as=0.3608p ps=2.52u w=0.82u l=1u
X1 VDD a_124_375# a_36_472# VNW pfet_05v0 ad=0.5368p pd=3.32u as=0.5368p ps=3.32u w=1.22u l=1u
.ends

.subckt gf180mcu_fd_sc_mcu7t5v0__tieh Z VDD VSS VNW VPW
X0 Z a_125_24# VDD VNW pfet_05v0 ad=0.5368p pd=3.32u as=0.5368p ps=3.32u w=1.22u l=0.5u
X1 a_125_24# a_125_24# VSS VPW nfet_05v0 ad=0.3608p pd=2.52u as=0.3608p ps=2.52u w=0.82u l=0.6u
.ends

.subckt gf180mcu_fd_sc_mcu7t5v0__inv_1 VSS ZN I VDD VNW VPW
X0 ZN I VSS VPW nfet_05v0 ad=0.3608p pd=2.52u as=0.3608p ps=2.52u w=0.82u l=0.6u
X1 ZN I VDD VNW pfet_05v0 ad=0.5368p pd=3.32u as=0.5368p ps=3.32u w=1.22u l=0.5u
.ends

.subckt gf180mcu_fd_sc_mcu7t5v0__nand2_1 VDD VSS ZN A1 A2 VNW VPW
X0 ZN A2 VDD VNW pfet_05v0 ad=0.2938p pd=1.65u as=0.4972p ps=3.14u w=1.13u l=0.5u
X1 ZN A1 a_245_68# VPW nfet_05v0 ad=0.3608p pd=2.52u as=0.1312p ps=1.14u w=0.82u l=0.6u
X2 VDD A1 ZN VNW pfet_05v0 ad=0.4972p pd=3.14u as=0.2938p ps=1.65u w=1.13u l=0.5u
X3 a_245_68# A2 VSS VPW nfet_05v0 ad=0.1312p pd=1.14u as=0.3608p ps=2.52u w=0.82u l=0.6u
.ends

.subckt gf180mcu_fd_sc_mcu7t5v0__dffrnq_1 D Q RN VSS CLK VDD VNW VPW
X0 VSS CLK a_36_151# VPW nfet_05v0 ad=0.1053p pd=0.925u as=0.1782p ps=1.69u w=0.405u l=0.6u
X1 VSS RN a_1456_156# VPW nfet_05v0 ad=0.2016p pd=1.48u as=43.2f ps=0.6u w=0.36u l=0.6u
X2 Q a_2665_112# VDD VNW pfet_05v0 ad=0.5346p pd=3.31u as=0.5346p ps=3.31u w=1.215u l=0.5u
X3 a_796_472# D VSS VPW nfet_05v0 ad=93.59999f pd=0.88u as=0.1584p ps=1.6u w=0.36u l=0.6u
X4 VSS a_2665_112# a_2560_156# VPW nfet_05v0 ad=0.1224p pd=1.04u as=94.5f ps=0.885u w=0.36u l=0.6u
X5 a_2665_112# a_2248_156# a_3041_156# VPW nfet_05v0 ad=0.176p pd=1.68u as=0.134p ps=1.1u w=0.4u l=0.6u
X6 a_1000_472# a_448_472# a_796_472# VNW pfet_05v0 ad=0.2028p pd=1.3u as=0.2028p ps=1.3u w=0.78u l=0.5u
X7 a_2248_156# a_36_151# a_1308_423# VNW pfet_05v0 ad=0.25375p pd=1.51u as=0.2424p ps=1.465u w=0.505u l=0.5u
X8 a_2248_156# a_448_472# a_1308_423# VPW nfet_05v0 ad=0.2007p pd=1.475u as=0.2007p ps=1.475u w=0.36u l=0.6u
X9 VDD CLK a_36_151# VNW pfet_05v0 ad=0.2249p pd=1.385u as=0.3806p ps=2.61u w=0.865u l=0.5u
X10 a_1456_156# a_1308_423# a_1288_156# VPW nfet_05v0 ad=43.2f pd=0.6u as=43.2f ps=0.6u w=0.36u l=0.6u
X11 a_1308_423# a_1000_472# VSS VPW nfet_05v0 ad=0.2007p pd=1.475u as=0.2016p ps=1.48u w=0.36u l=0.6u
X12 Q a_2665_112# VSS VPW nfet_05v0 ad=0.3586p pd=2.51u as=0.3586p ps=2.51u w=0.815u l=0.6u
X13 a_448_472# a_36_151# VDD VNW pfet_05v0 ad=0.3806p pd=2.61u as=0.2249p ps=1.385u w=0.865u l=0.5u
X14 a_1204_472# a_36_151# a_1000_472# VNW pfet_05v0 ad=0.2028p pd=1.3u as=0.2028p ps=1.3u w=0.78u l=0.5u
X15 a_1204_472# RN VDD VNW pfet_05v0 ad=0.3432p pd=2.44u as=0.45p ps=2.02u w=0.78u l=0.5u
X16 a_2665_112# RN VDD VNW pfet_05v0 ad=0.26p pd=1.52u as=0.29465p ps=1.74u w=1u l=0.5u
X17 a_2560_156# a_36_151# a_2248_156# VPW nfet_05v0 ad=94.5f pd=0.885u as=0.2007p ps=1.475u w=0.36u l=0.6u
X18 VDD a_2248_156# a_2665_112# VNW pfet_05v0 ad=0.44p pd=2.88u as=0.26p ps=1.52u w=1u l=0.5u
X19 a_1288_156# a_448_472# a_1000_472# VPW nfet_05v0 ad=43.2f pd=0.6u as=93.59999f ps=0.88u w=0.36u l=0.6u
X20 VDD a_1308_423# a_1204_472# VNW pfet_05v0 ad=0.45p pd=2.02u as=0.2028p ps=1.3u w=0.78u l=0.5u
X21 a_2560_156# a_448_472# a_2248_156# VNW pfet_05v0 ad=0.1313p pd=1.025u as=0.25375p ps=1.51u w=0.505u l=0.5u
X22 a_448_472# a_36_151# VSS VPW nfet_05v0 ad=0.1782p pd=1.69u as=0.1053p ps=0.925u w=0.405u l=0.6u
X23 a_3041_156# RN VSS VPW nfet_05v0 ad=0.134p pd=1.1u as=0.1224p ps=1.04u w=0.36u l=0.6u
X24 VDD a_2665_112# a_2560_156# VNW pfet_05v0 ad=0.29465p pd=1.74u as=0.1313p ps=1.025u w=0.505u l=0.5u
X25 a_1308_423# a_1000_472# VDD VNW pfet_05v0 ad=0.2424p pd=1.465u as=0.2222p ps=1.89u w=0.505u l=0.5u
X26 a_1000_472# a_36_151# a_796_472# VPW nfet_05v0 ad=93.59999f pd=0.88u as=93.59999f ps=0.88u w=0.36u l=0.6u
X27 a_796_472# D VDD VNW pfet_05v0 ad=0.2028p pd=1.3u as=0.3432p ps=2.44u w=0.78u l=0.5u
.ends

.subckt PFD_lib DOWN FB UP REF VDD VSS
XFILLER_3_36 VDD VSS VDD VSS gf180mcu_fd_sc_mcu7t5v0__fillcap_8
XFILLER_3_2 VDD VSS VDD VSS gf180mcu_fd_sc_mcu7t5v0__fillcap_32
XFILLER_0_36 VDD VSS VDD VSS gf180mcu_fd_sc_mcu7t5v0__fillcap_32
XFILLER_3_59 VDD VSS VDD VSS gf180mcu_fd_sc_mcu7t5v0__fillcap_8
XFILLER_1_2 VDD VSS VDD VSS gf180mcu_fd_sc_mcu7t5v0__fillcap_16
XFILLER_1_72 VDD VSS VDD VSS gf180mcu_fd_sc_mcu7t5v0__fillcap_16
XFILLER_1_61 VDD VSS VDD VSS gf180mcu_fd_sc_mcu7t5v0__fillcap_8
XFILLER_1_88 VDD VSS VDD VSS gf180mcu_fd_sc_mcu7t5v0__fillcap_4
XX2_2 X2/D VDD VSS VDD VSS gf180mcu_fd_sc_mcu7t5v0__tieh
XXI1 VSS XI2/I XN/ZN VDD VDD VSS gf180mcu_fd_sc_mcu7t5v0__inv_1
XXI2 VSS X2/RN XI2/I VDD VDD VSS gf180mcu_fd_sc_mcu7t5v0__inv_1
XFILLER_2_71 VDD VSS VDD VSS gf180mcu_fd_sc_mcu7t5v0__fillcap_16
XFILLER_1_18 VDD VSS VDD VSS gf180mcu_fd_sc_mcu7t5v0__fillcap_8
XFILLER_2_2 VDD VSS VDD VSS gf180mcu_fd_sc_mcu7t5v0__fillcap_16
XFILLER_2_87 VDD VSS VDD VSS gf180mcu_fd_sc_mcu7t5v0__fillcap_4
XFILLER_0_2 VDD VSS VDD VSS gf180mcu_fd_sc_mcu7t5v0__fillcap_32
XFILLER_2_24 VDD VSS VDD VSS gf180mcu_fd_sc_mcu7t5v0__fillcap_4
XXN VDD VSS XN/ZN UP DOWN VDD VSS gf180mcu_fd_sc_mcu7t5v0__nand2_1
XFILLER_0_70 VDD VSS VDD VSS gf180mcu_fd_sc_mcu7t5v0__fillcap_16
XFILLER_3_70 VDD VSS VDD VSS gf180mcu_fd_sc_mcu7t5v0__fillcap_16
XFILLER_0_86 VDD VSS VDD VSS gf180mcu_fd_sc_mcu7t5v0__fillcap_4
XFILLER_3_86 VDD VSS VDD VSS gf180mcu_fd_sc_mcu7t5v0__fillcap_4
XX1 X1/D UP X2/RN VSS REF VDD VDD VSS gf180mcu_fd_sc_mcu7t5v0__dffrnq_1
XX1_1 X1/D VDD VSS VDD VSS gf180mcu_fd_sc_mcu7t5v0__tieh
XX2 X2/D DOWN X2/RN VSS FB VDD VDD VSS gf180mcu_fd_sc_mcu7t5v0__dffrnq_1
.ends

.subckt vco_tune_r TUNE cap_bias GND
X0 TUNE cap_bias GND ppolyf_u_1k r_width=1u r_length=15u
.ends

.subckt vco_varactors cap_bias OUT_n OUT_p
X0 cap_bias OUT_n cap_nmos_03v3_b c_width=5u c_length=5u
X1 cap_bias OUT_p cap_nmos_03v3_b c_width=5u c_length=5u
X2 cap_bias OUT_p cap_nmos_03v3_b c_width=5u c_length=5u
X3 cap_bias OUT_n cap_nmos_03v3_b c_width=5u c_length=5u
X4 cap_bias OUT_n cap_nmos_03v3_b c_width=5u c_length=5u
X5 cap_bias OUT_n cap_nmos_03v3_b c_width=5u c_length=5u
X6 cap_bias OUT_p cap_nmos_03v3_b c_width=5u c_length=5u
X7 cap_bias OUT_n cap_nmos_03v3_b c_width=5u c_length=5u
X8 cap_bias OUT_p cap_nmos_03v3_b c_width=5u c_length=5u
X9 cap_bias OUT_n cap_nmos_03v3_b c_width=5u c_length=5u
X10 cap_bias OUT_n cap_nmos_03v3_b c_width=5u c_length=5u
X11 cap_bias OUT_p cap_nmos_03v3_b c_width=5u c_length=5u
X12 cap_bias OUT_p cap_nmos_03v3_b c_width=5u c_length=5u
X13 cap_bias OUT_n cap_nmos_03v3_b c_width=5u c_length=5u
X14 cap_bias OUT_n cap_nmos_03v3_b c_width=5u c_length=5u
X15 cap_bias OUT_n cap_nmos_03v3_b c_width=5u c_length=5u
X16 cap_bias OUT_p cap_nmos_03v3_b c_width=5u c_length=5u
X17 cap_bias OUT_n cap_nmos_03v3_b c_width=5u c_length=5u
X18 cap_bias OUT_n cap_nmos_03v3_b c_width=5u c_length=5u
X19 cap_bias OUT_p cap_nmos_03v3_b c_width=5u c_length=5u
X20 cap_bias OUT_p cap_nmos_03v3_b c_width=5u c_length=5u
X21 cap_bias OUT_p cap_nmos_03v3_b c_width=5u c_length=5u
X22 cap_bias OUT_p cap_nmos_03v3_b c_width=5u c_length=5u
X23 cap_bias OUT_p cap_nmos_03v3_b c_width=5u c_length=5u
X24 cap_bias OUT_p cap_nmos_03v3_b c_width=5u c_length=5u
X25 cap_bias OUT_n cap_nmos_03v3_b c_width=5u c_length=5u
X26 cap_bias OUT_n cap_nmos_03v3_b c_width=5u c_length=5u
X27 cap_bias OUT_n cap_nmos_03v3_b c_width=5u c_length=5u
X28 cap_bias OUT_p cap_nmos_03v3_b c_width=5u c_length=5u
X29 cap_bias OUT_p cap_nmos_03v3_b c_width=5u c_length=5u
X30 cap_bias OUT_n cap_nmos_03v3_b c_width=5u c_length=5u
X31 cap_bias OUT_n cap_nmos_03v3_b c_width=5u c_length=5u
X32 cap_bias OUT_p cap_nmos_03v3_b c_width=5u c_length=5u
X33 cap_bias OUT_p cap_nmos_03v3_b c_width=5u c_length=5u
X34 cap_bias OUT_n cap_nmos_03v3_b c_width=5u c_length=5u
X35 cap_bias OUT_n cap_nmos_03v3_b c_width=5u c_length=5u
X36 cap_bias OUT_n cap_nmos_03v3_b c_width=5u c_length=5u
X37 cap_bias OUT_n cap_nmos_03v3_b c_width=5u c_length=5u
X38 cap_bias OUT_p cap_nmos_03v3_b c_width=5u c_length=5u
X39 cap_bias OUT_p cap_nmos_03v3_b c_width=5u c_length=5u
X40 cap_bias OUT_p cap_nmos_03v3_b c_width=5u c_length=5u
X41 cap_bias OUT_p cap_nmos_03v3_b c_width=5u c_length=5u
.ends

.subckt vco_inductor_v2 PORT1 PORT2
X0 PORT2 m4_n14800_800# tm11k r_width=8u r_length=76u
X1 m4_n14800_800# PORT1 tm11k r_width=8u r_length=76u
.ends

.subckt vco_core ISS VDD GND OUT_p OUT_n
X0 OUT_n OUT_p ISS GND nfet_03v3 ad=1.04p pd=4.52u as=1.76p ps=8.88u w=4u l=0.28u
X1 ISS OUT_p OUT_n GND nfet_03v3 ad=1.04p pd=4.52u as=1.04p ps=4.52u w=4u l=0.28u
X2 OUT_p OUT_n VDD VDD pfet_03v3 ad=3.64p pd=14.52u as=6.16p ps=28.88u w=14u l=0.28u
X3 OUT_n OUT_p ISS GND nfet_03v3 ad=1.04p pd=4.52u as=1.04p ps=4.52u w=4u l=0.28u
X4 OUT_p OUT_n VDD VDD pfet_03v3 ad=6.16p pd=28.88u as=3.64p ps=14.52u w=14u l=0.28u
X5 OUT_p OUT_n VDD VDD pfet_03v3 ad=3.64p pd=14.52u as=3.64p ps=14.52u w=14u l=0.28u
X6 VDD OUT_n OUT_p VDD pfet_03v3 ad=3.64p pd=14.52u as=3.64p ps=14.52u w=14u l=0.28u
X7 OUT_p OUT_n ISS GND nfet_03v3 ad=1.04p pd=4.52u as=1.76p ps=8.88u w=4u l=0.28u
X8 OUT_n OUT_p ISS GND nfet_03v3 ad=1.04p pd=4.52u as=1.04p ps=4.52u w=4u l=0.28u
X9 ISS OUT_n OUT_p GND nfet_03v3 ad=1.76p pd=8.88u as=1.04p ps=4.52u w=4u l=0.28u
X10 VDD OUT_n OUT_p VDD pfet_03v3 ad=3.64p pd=14.52u as=3.64p ps=14.52u w=14u l=0.28u
X11 ISS OUT_p OUT_n GND nfet_03v3 ad=1.04p pd=4.52u as=1.04p ps=4.52u w=4u l=0.28u
X12 ISS OUT_p OUT_n GND nfet_03v3 ad=1.04p pd=4.52u as=1.04p ps=4.52u w=4u l=0.28u
X13 OUT_p OUT_n ISS GND nfet_03v3 ad=1.04p pd=4.52u as=1.04p ps=4.52u w=4u l=0.28u
X14 OUT_n OUT_p VDD VDD pfet_03v3 ad=3.64p pd=14.52u as=3.64p ps=14.52u w=14u l=0.28u
X15 ISS OUT_n OUT_p GND nfet_03v3 ad=1.04p pd=4.52u as=1.04p ps=4.52u w=4u l=0.28u
X16 OUT_n OUT_p VDD VDD pfet_03v3 ad=6.16p pd=28.88u as=3.64p ps=14.52u w=14u l=0.28u
X17 OUT_p OUT_n ISS GND nfet_03v3 ad=1.04p pd=4.52u as=1.04p ps=4.52u w=4u l=0.28u
X18 VDD OUT_p OUT_n VDD pfet_03v3 ad=3.64p pd=14.52u as=3.64p ps=14.52u w=14u l=0.28u
X19 VDD OUT_p OUT_n VDD pfet_03v3 ad=3.64p pd=14.52u as=3.64p ps=14.52u w=14u l=0.28u
X20 OUT_n OUT_p ISS GND nfet_03v3 ad=1.04p pd=4.52u as=1.04p ps=4.52u w=4u l=0.28u
X21 ISS OUT_n OUT_p GND nfet_03v3 ad=1.04p pd=4.52u as=1.04p ps=4.52u w=4u l=0.28u
X22 ISS OUT_n OUT_p GND nfet_03v3 ad=1.04p pd=4.52u as=1.04p ps=4.52u w=4u l=0.28u
X23 ISS OUT_p OUT_n GND nfet_03v3 ad=1.04p pd=4.52u as=1.04p ps=4.52u w=4u l=0.28u
X24 OUT_p OUT_n ISS GND nfet_03v3 ad=1.04p pd=4.52u as=1.04p ps=4.52u w=4u l=0.28u
X25 ISS OUT_p OUT_n GND nfet_03v3 ad=1.76p pd=8.88u as=1.04p ps=4.52u w=4u l=0.28u
X26 OUT_n OUT_p ISS GND nfet_03v3 ad=1.04p pd=4.52u as=1.04p ps=4.52u w=4u l=0.28u
X27 ISS OUT_n OUT_p GND nfet_03v3 ad=1.04p pd=4.52u as=1.04p ps=4.52u w=4u l=0.28u
X28 OUT_n OUT_p VDD VDD pfet_03v3 ad=3.64p pd=14.52u as=6.16p ps=28.88u w=14u l=0.28u
X29 OUT_p OUT_n ISS GND nfet_03v3 ad=1.04p pd=4.52u as=1.04p ps=4.52u w=4u l=0.28u
.ends

.subckt vco_v1 TUNE GND VDD ISS OUT_p OUT_n
Xvco_tune_r_0 TUNE vco_tune_r_0/cap_bias GND vco_tune_r
Xvco_varactors_0 vco_tune_r_0/cap_bias OUT_n OUT_p vco_varactors
Xvco_inductor_v2_0 OUT_n OUT_p vco_inductor_v2
Xvco_core_0 ISS VDD GND OUT_p OUT_n vco_core
.ends

.subckt esd_rpoly a_n1600_400# a_n1600_n502# VSUBS
X0 a_n1600_400# a_n1600_n502# VSUBS ppolyf_u r_width=16u r_length=4u
.ends

.subckt esd_nd2ps a_100_100# a_n2100_100# a_n2100_n2100# a_100_n2100# a_n2236_n2236#
D0 a_n2236_n2236# a_100_100# diode_nd2ps_03v3 pj=40u area=99.99999p
D1 a_n2236_n2236# a_100_n2100# diode_nd2ps_03v3 pj=40u area=99.99999p
D2 a_n2236_n2236# a_n2100_100# diode_nd2ps_03v3 pj=40u area=99.99999p
D3 a_n2236_n2236# a_n2100_n2100# diode_nd2ps_03v3 pj=40u area=99.99999p
.ends

.subckt esd_pd2nw a_100_100# a_n2100_100# a_n2100_n2100# w_n2260_n2260# a_100_n2100#
D0 a_100_100# w_n2260_n2260# diode_pd2nw_03v3 pj=40u area=99.99999p
D1 a_100_n2100# w_n2260_n2260# diode_pd2nw_03v3 pj=40u area=99.99999p
D2 a_n2100_100# w_n2260_n2260# diode_pd2nw_03v3 pj=40u area=99.99999p
D3 a_n2100_n2100# w_n2260_n2260# diode_pd2nw_03v3 pj=40u area=99.99999p
.ends

.subckt CP_v1 VGP VGN DOWN CP_OUT UP VDD VSS
X0 CP_OUT UPB PMID VDD pfet_03v3 ad=1.3p pd=5.52u as=2.2p ps=10.88u w=5u l=0.3u
X1 UPB UP VSS VSS nfet_03v3 ad=0.44p pd=2.88u as=0.44p ps=2.88u w=1u l=0.3u
X2 PMID UPB CP_OUT VDD pfet_03v3 ad=2.2p pd=10.88u as=1.3p ps=5.52u w=5u l=0.3u
X3 VGN VGN VSS VSS nfet_03v3 ad=1.3p pd=5.52u as=2.2p ps=10.88u w=5u l=2u
X4 VSS VGN NMID VSS nfet_03v3 ad=2.2p pd=10.88u as=1.3p ps=5.52u w=5u l=2u
X5 NMID VGN VSS VSS nfet_03v3 ad=1.3p pd=5.52u as=1.3p ps=5.52u w=5u l=2u
X6 VDD VGP PMID VDD pfet_03v3 ad=1.3p pd=5.52u as=1.3p ps=5.52u w=5u l=2u
X7 CP_OUT DOWN NMID VSS nfet_03v3 ad=1.3p pd=5.52u as=2.2p ps=10.88u w=5u l=0.3u
X8 UPB UP VDD VDD pfet_03v3 ad=0.88p pd=4.88u as=0.88p ps=4.88u w=2u l=0.3u
X9 CP_OUT UPB PMID VDD pfet_03v3 ad=1.3p pd=5.52u as=1.3p ps=5.52u w=5u l=0.3u
X10 VGP VGP VDD VDD pfet_03v3 ad=1.3p pd=5.52u as=1.3p ps=5.52u w=5u l=2u
X11 VDD VGP PMID VDD pfet_03v3 ad=2.2p pd=10.88u as=1.3p ps=5.52u w=5u l=2u
X12 VDD VGP VGP VDD pfet_03v3 ad=1.3p pd=5.52u as=1.3p ps=5.52u w=5u l=2u
X13 PMID VGP VDD VDD pfet_03v3 ad=1.3p pd=5.52u as=1.3p ps=5.52u w=5u l=2u
X14 CP_OUT UPB PMID VDD pfet_03v3 ad=1.3p pd=5.52u as=1.3p ps=5.52u w=5u l=0.3u
X15 CP_OUT UPB PMID VDD pfet_03v3 ad=1.3p pd=5.52u as=1.3p ps=5.52u w=5u l=0.3u
X16 VGP VGP VDD VDD pfet_03v3 ad=1.3p pd=5.52u as=1.3p ps=5.52u w=5u l=2u
X17 NMID DOWN CP_OUT VSS nfet_03v3 ad=2.2p pd=10.88u as=1.3p ps=5.52u w=5u l=0.3u
X18 PMID VGP VDD VDD pfet_03v3 ad=1.3p pd=5.52u as=1.3p ps=5.52u w=5u l=2u
X19 VDD VGP VGP VDD pfet_03v3 ad=1.3p pd=5.52u as=1.3p ps=5.52u w=5u l=2u
X20 VDD VGP PMID VDD pfet_03v3 ad=1.3p pd=5.52u as=1.3p ps=5.52u w=5u l=2u
X21 PMID VGP VDD VDD pfet_03v3 ad=1.3p pd=5.52u as=1.3p ps=5.52u w=5u l=2u
X22 VDD VGP VGP VDD pfet_03v3 ad=1.3p pd=5.52u as=1.3p ps=5.52u w=5u l=2u
X23 PMID UPB CP_OUT VDD pfet_03v3 ad=1.3p pd=5.52u as=1.3p ps=5.52u w=5u l=0.3u
X24 VGP VGP VDD VDD pfet_03v3 ad=1.3p pd=5.52u as=1.3p ps=5.52u w=5u l=2u
X25 PMID VGP VDD VDD pfet_03v3 ad=1.3p pd=5.52u as=1.3p ps=5.52u w=5u l=2u
X26 VGP VGP VDD VDD pfet_03v3 ad=1.3p pd=5.52u as=2.2p ps=10.88u w=5u l=2u
X27 VDD VGP PMID VDD pfet_03v3 ad=1.3p pd=5.52u as=1.3p ps=5.52u w=5u l=2u
X28 PMID UPB CP_OUT VDD pfet_03v3 ad=1.3p pd=5.52u as=1.3p ps=5.52u w=5u l=0.3u
X29 PMID VGP VDD VDD pfet_03v3 ad=1.3p pd=5.52u as=1.3p ps=5.52u w=5u l=2u
X30 VSS VGN VGN VSS nfet_03v3 ad=1.3p pd=5.52u as=1.3p ps=5.52u w=5u l=2u
X31 VGP VGP VDD VDD pfet_03v3 ad=1.3p pd=5.52u as=1.3p ps=5.52u w=5u l=2u
X32 PMID UPB CP_OUT VDD pfet_03v3 ad=1.3p pd=5.52u as=1.3p ps=5.52u w=5u l=0.3u
X33 VDD VGP PMID VDD pfet_03v3 ad=1.3p pd=5.52u as=1.3p ps=5.52u w=5u l=2u
X34 CP_OUT UPB PMID VDD pfet_03v3 ad=1.3p pd=5.52u as=1.3p ps=5.52u w=5u l=0.3u
X35 VDD VGP VGP VDD pfet_03v3 ad=1.3p pd=5.52u as=1.3p ps=5.52u w=5u l=2u
X36 PMID UPB CP_OUT VDD pfet_03v3 ad=1.3p pd=5.52u as=1.3p ps=5.52u w=5u l=0.3u
X37 VDD VGP VGP VDD pfet_03v3 ad=1.3p pd=5.52u as=1.3p ps=5.52u w=5u l=2u
.ends

.subckt ib_conv_v1 OUT VSS IBIAS INP INM VDD
X0 a_938_3424# INP a_100_n800# VSS nfet_03v3 ad=3.52p pd=16.88u as=3.52p ps=16.88u w=8u l=0.3u
X1 a_938_3424# a_938_3424# VDD VDD pfet_03v3 ad=3.52p pd=16.88u as=3.52p ps=16.88u w=8u l=0.3u
X2 a_8030_n1600# a_6430_n1100# VDD VDD pfet_03v3 ad=19.36p pd=88.88u as=19.36p ps=88.88u w=44u l=0.3u
X3 a_8030_n1600# a_6430_n1100# VSS VSS nfet_03v3 ad=7.04p pd=32.88u as=7.04p ps=32.88u w=16u l=0.3u
X4 a_6430_n1100# a_2156_7176# VDD VDD pfet_03v3 ad=11.44p pd=52.88u as=11.44p ps=52.88u w=26u l=0.3u
X5 a_2430_n800# INM a_100_n800# VSS nfet_03v3 ad=3.52p pd=16.88u as=3.52p ps=16.88u w=8u l=0.3u
X6 a_6430_n1100# a_2156_7176# VSS VSS nfet_03v3 ad=4.84p pd=22.88u as=4.84p ps=22.88u w=11u l=0.3u
X7 OUT a_8030_n1600# VSS ppolyf_u_1k r_width=2u r_length=2u
X8 a_2156_7176# a_1676_7176# VSS VSS nfet_03v3 ad=1.76p pd=8.88u as=1.76p ps=8.88u w=4u l=0.3u
X9 a_100_n800# IBIAS VSS VSS nfet_03v3 ad=3.52p pd=16.88u as=3.52p ps=16.88u w=8u l=1u
X10 a_2156_7176# a_1676_7176# VDD VDD pfet_03v3 ad=4.4p pd=20.88u as=4.4p ps=20.88u w=10u l=0.3u
X11 a_2430_n800# a_938_3424# VDD VDD pfet_03v3 ad=3.52p pd=16.88u as=3.52p ps=16.88u w=8u l=0.3u
X12 a_2430_n800# a_1676_7176# cap_mim_2f0_m4m5_noshield c_width=5u c_length=10u
X13 a_2156_7176# a_1676_7176# VSS ppolyf_u_1k r_width=2u r_length=40.04u
.ends

.subckt DIV2_QUAD_v1 Q_P CK CKB IBIAS VSS VDD I_P I_N Q_N
Xib_conv_v1_0 I_P VSS IBIAS OIB OI VDD ib_conv_v1
Xib_conv_v1_1 I_N VSS IBIAS OI OIB VDD ib_conv_v1
Xib_conv_v1_2 Q_N VSS IBIAS OQ OQB VDD ib_conv_v1
Xib_conv_v1_3 Q_P VSS IBIAS OQB OQ VDD ib_conv_v1
X0 OQ OQB a_4344_n7400# VSS nfet_03v3 ad=1.04p pd=4.52u as=1.76p ps=8.88u w=4u l=0.3u
X1 OQ OI a_n708_n7400# VSS nfet_03v3 ad=1.04p pd=4.52u as=1.04p ps=4.52u w=4u l=0.3u
X2 VDD OQB VSS ppolyf_u_1k r_width=10u r_length=3u
X3 a_4344_n400# OI OIB VSS nfet_03v3 ad=1.76p pd=8.88u as=1.04p ps=4.52u w=4u l=0.3u
X4 OI OQB a_n708_n400# VSS nfet_03v3 ad=1.04p pd=4.52u as=1.76p ps=8.88u w=4u l=0.3u
X5 a_4344_n400# CKB a_n856_n400# VSS nfet_03v3 ad=1.04p pd=4.52u as=1.04p ps=4.52u w=4u l=0.3u
X6 OI OIB a_4344_n400# VSS nfet_03v3 ad=1.04p pd=4.52u as=1.04p ps=4.52u w=4u l=0.3u
X7 OQB OQ a_4344_n7400# VSS nfet_03v3 ad=1.04p pd=4.52u as=1.04p ps=4.52u w=4u l=0.3u
X8 a_4344_n400# CKB a_n856_n400# VSS nfet_03v3 ad=1.04p pd=4.52u as=1.04p ps=4.52u w=4u l=0.3u
X9 a_n708_n400# OQ OIB VSS nfet_03v3 ad=1.04p pd=4.52u as=1.04p ps=4.52u w=4u l=0.3u
X10 a_n708_n7400# OIB OQB VSS nfet_03v3 ad=1.04p pd=4.52u as=1.04p ps=4.52u w=4u l=0.3u
X11 a_n856_n7400# CK a_4344_n7400# VSS nfet_03v3 ad=1.04p pd=4.52u as=1.04p ps=4.52u w=4u l=0.3u
X12 a_n856_n7400# CKB a_n708_n7400# VSS nfet_03v3 ad=1.04p pd=4.52u as=1.04p ps=4.52u w=4u l=0.3u
X13 a_n856_n7400# CKB a_n708_n7400# VSS nfet_03v3 ad=1.04p pd=4.52u as=1.04p ps=4.52u w=4u l=0.3u
X14 a_n856_n400# CKB a_4344_n400# VSS nfet_03v3 ad=1.04p pd=4.52u as=1.04p ps=4.52u w=4u l=0.3u
X15 OIB OQ a_n708_n400# VSS nfet_03v3 ad=1.04p pd=4.52u as=1.04p ps=4.52u w=4u l=0.3u
X16 a_n856_n400# CK a_n708_n400# VSS nfet_03v3 ad=1.04p pd=4.52u as=1.04p ps=4.52u w=4u l=0.3u
X17 a_4344_n400# OIB OI VSS nfet_03v3 ad=1.04p pd=4.52u as=1.04p ps=4.52u w=4u l=0.3u
X18 VSS IBIAS a_n856_n400# VSS nfet_03v3 ad=1.04p pd=4.52u as=1.04p ps=4.52u w=4u l=1u
X19 OI OIB a_4344_n400# VSS nfet_03v3 ad=1.04p pd=4.52u as=1.04p ps=4.52u w=4u l=0.3u
X20 a_n856_n7400# CK a_4344_n7400# VSS nfet_03v3 ad=1.04p pd=4.52u as=1.04p ps=4.52u w=4u l=0.3u
X21 OQB OIB a_n708_n7400# VSS nfet_03v3 ad=1.04p pd=4.52u as=1.04p ps=4.52u w=4u l=0.3u
X22 VSS IBIAS a_n856_n7400# VSS nfet_03v3 ad=1.04p pd=4.52u as=1.04p ps=4.52u w=4u l=1u
X23 a_4344_n7400# OQ OQB VSS nfet_03v3 ad=1.76p pd=8.88u as=1.04p ps=4.52u w=4u l=0.3u
X24 a_n856_n7400# CK a_4344_n7400# VSS nfet_03v3 ad=1.04p pd=4.52u as=1.04p ps=4.52u w=4u l=0.3u
X25 a_4344_n7400# CK a_n856_n7400# VSS nfet_03v3 ad=1.04p pd=4.52u as=1.04p ps=4.52u w=4u l=0.3u
X26 a_n856_n7400# CKB a_n708_n7400# VSS nfet_03v3 ad=1.04p pd=4.52u as=1.04p ps=4.52u w=4u l=0.3u
X27 a_n856_n400# IBIAS VSS VSS nfet_03v3 ad=1.04p pd=4.52u as=1.04p ps=4.52u w=4u l=1u
X28 a_n708_n400# OQ OIB VSS nfet_03v3 ad=1.04p pd=4.52u as=1.04p ps=4.52u w=4u l=0.3u
X29 OI OIB a_4344_n400# VSS nfet_03v3 ad=1.04p pd=4.52u as=1.04p ps=4.52u w=4u l=0.3u
X30 a_n708_n400# CK a_n856_n400# VSS nfet_03v3 ad=1.04p pd=4.52u as=1.04p ps=4.52u w=4u l=0.3u
X31 a_4344_n7400# OQB OQ VSS nfet_03v3 ad=1.04p pd=4.52u as=1.04p ps=4.52u w=4u l=0.3u
X32 a_n708_n400# OQ OIB VSS nfet_03v3 ad=1.04p pd=4.52u as=1.04p ps=4.52u w=4u l=0.3u
X33 VSS IBIAS a_n856_n400# VSS nfet_03v3 ad=1.76p pd=8.88u as=1.04p ps=4.52u w=4u l=1u
X34 OI OQB a_n708_n400# VSS nfet_03v3 ad=1.04p pd=4.52u as=1.04p ps=4.52u w=4u l=0.3u
X35 a_n856_n400# IBIAS VSS VSS nfet_03v3 ad=1.04p pd=4.52u as=1.04p ps=4.52u w=4u l=1u
X36 a_n856_n400# CKB a_4344_n400# VSS nfet_03v3 ad=1.04p pd=4.52u as=1.04p ps=4.52u w=4u l=0.3u
X37 a_n708_n400# OQB OI VSS nfet_03v3 ad=1.76p pd=8.88u as=1.04p ps=4.52u w=4u l=0.3u
X38 a_4344_n400# OIB OI VSS nfet_03v3 ad=1.04p pd=4.52u as=1.04p ps=4.52u w=4u l=0.3u
X39 a_4344_n7400# OQB OQ VSS nfet_03v3 ad=1.04p pd=4.52u as=1.04p ps=4.52u w=4u l=0.3u
X40 OQ OQB a_4344_n7400# VSS nfet_03v3 ad=1.04p pd=4.52u as=1.04p ps=4.52u w=4u l=0.3u
X41 OIB OQ a_n708_n400# VSS nfet_03v3 ad=1.04p pd=4.52u as=1.76p ps=8.88u w=4u l=0.3u
X42 a_4344_n7400# OQB OQ VSS nfet_03v3 ad=1.04p pd=4.52u as=1.04p ps=4.52u w=4u l=0.3u
X43 a_n708_n7400# OI OQ VSS nfet_03v3 ad=1.04p pd=4.52u as=1.04p ps=4.52u w=4u l=0.3u
X44 OQB OQ a_4344_n7400# VSS nfet_03v3 ad=1.04p pd=4.52u as=1.04p ps=4.52u w=4u l=0.3u
X45 OI OQB a_n708_n400# VSS nfet_03v3 ad=1.04p pd=4.52u as=1.04p ps=4.52u w=4u l=0.3u
X46 a_n856_n400# CK a_n708_n400# VSS nfet_03v3 ad=1.76p pd=8.88u as=1.04p ps=4.52u w=4u l=0.3u
X47 OIB OI a_4344_n400# VSS nfet_03v3 ad=1.04p pd=4.52u as=1.04p ps=4.52u w=4u l=0.3u
X48 a_n856_n7400# CKB a_n708_n7400# VSS nfet_03v3 ad=1.04p pd=4.52u as=1.04p ps=4.52u w=4u l=0.3u
X49 a_n708_n7400# CKB a_n856_n7400# VSS nfet_03v3 ad=1.04p pd=4.52u as=1.04p ps=4.52u w=4u l=0.3u
X50 a_n856_n400# CKB a_4344_n400# VSS nfet_03v3 ad=1.04p pd=4.52u as=1.04p ps=4.52u w=4u l=0.3u
X51 a_4344_n400# OIB OI VSS nfet_03v3 ad=1.04p pd=4.52u as=1.04p ps=4.52u w=4u l=0.3u
X52 a_4344_n7400# CK a_n856_n7400# VSS nfet_03v3 ad=1.04p pd=4.52u as=1.04p ps=4.52u w=4u l=0.3u
X53 a_n856_n7400# CK a_4344_n7400# VSS nfet_03v3 ad=1.76p pd=8.88u as=1.04p ps=4.52u w=4u l=0.3u
X54 a_n708_n7400# CKB a_n856_n7400# VSS nfet_03v3 ad=1.04p pd=4.52u as=1.76p ps=8.88u w=4u l=0.3u
X55 a_4344_n7400# OQ OQB VSS nfet_03v3 ad=1.04p pd=4.52u as=1.04p ps=4.52u w=4u l=0.3u
X56 a_n856_n7400# IBIAS VSS VSS nfet_03v3 ad=1.04p pd=4.52u as=1.04p ps=4.52u w=4u l=1u
X57 OQB OIB a_n708_n7400# VSS nfet_03v3 ad=1.04p pd=4.52u as=1.76p ps=8.88u w=4u l=0.3u
X58 OQ OI a_n708_n7400# VSS nfet_03v3 ad=1.04p pd=4.52u as=1.76p ps=8.88u w=4u l=0.3u
X59 a_n856_n400# IBIAS VSS VSS nfet_03v3 ad=1.04p pd=4.52u as=1.76p ps=8.88u w=4u l=1u
X60 a_4344_n400# CKB a_n856_n400# VSS nfet_03v3 ad=1.04p pd=4.52u as=1.04p ps=4.52u w=4u l=0.3u
X61 OQ OQB a_4344_n7400# VSS nfet_03v3 ad=1.04p pd=4.52u as=1.04p ps=4.52u w=4u l=0.3u
X62 VSS IBIAS a_n856_n7400# VSS nfet_03v3 ad=1.04p pd=4.52u as=1.04p ps=4.52u w=4u l=1u
X63 VSS IBIAS a_n856_n400# VSS nfet_03v3 ad=1.04p pd=4.52u as=1.04p ps=4.52u w=4u l=1u
X64 OIB OI a_4344_n400# VSS nfet_03v3 ad=1.04p pd=4.52u as=1.04p ps=4.52u w=4u l=0.3u
X65 a_4344_n7400# OQB OQ VSS nfet_03v3 ad=1.76p pd=8.88u as=1.04p ps=4.52u w=4u l=0.3u
X66 OQ OI a_n708_n7400# VSS nfet_03v3 ad=1.04p pd=4.52u as=1.04p ps=4.52u w=4u l=0.3u
X67 a_n708_n7400# OIB OQB VSS nfet_03v3 ad=1.04p pd=4.52u as=1.04p ps=4.52u w=4u l=0.3u
X68 a_n856_n400# CKB a_4344_n400# VSS nfet_03v3 ad=1.04p pd=4.52u as=1.04p ps=4.52u w=4u l=0.3u
X69 IBIAS IBIAS VSS VSS nfet_03v3 ad=1.76p pd=8.88u as=1.76p ps=8.88u w=4u l=1u
X70 OIB OQ a_n708_n400# VSS nfet_03v3 ad=1.04p pd=4.52u as=1.04p ps=4.52u w=4u l=0.3u
X71 a_4344_n7400# CK a_n856_n7400# VSS nfet_03v3 ad=1.04p pd=4.52u as=1.04p ps=4.52u w=4u l=0.3u
X72 a_n708_n400# OQB OI VSS nfet_03v3 ad=1.04p pd=4.52u as=1.04p ps=4.52u w=4u l=0.3u
X73 a_n856_n7400# CKB a_n708_n7400# VSS nfet_03v3 ad=1.76p pd=8.88u as=1.04p ps=4.52u w=4u l=0.3u
X74 a_4344_n400# OI OIB VSS nfet_03v3 ad=1.04p pd=4.52u as=1.04p ps=4.52u w=4u l=0.3u
X75 a_4344_n400# CKB a_n856_n400# VSS nfet_03v3 ad=1.04p pd=4.52u as=1.76p ps=8.88u w=4u l=0.3u
X76 OI OIB a_4344_n400# VSS nfet_03v3 ad=1.04p pd=4.52u as=1.04p ps=4.52u w=4u l=0.3u
X77 OQB OQ a_4344_n7400# VSS nfet_03v3 ad=1.04p pd=4.52u as=1.04p ps=4.52u w=4u l=0.3u
X78 a_n856_n7400# CK a_4344_n7400# VSS nfet_03v3 ad=1.04p pd=4.52u as=1.04p ps=4.52u w=4u l=0.3u
X79 OQ OQB a_4344_n7400# VSS nfet_03v3 ad=1.04p pd=4.52u as=1.04p ps=4.52u w=4u l=0.3u
X80 a_n856_n400# CKB a_4344_n400# VSS nfet_03v3 ad=1.76p pd=8.88u as=1.04p ps=4.52u w=4u l=0.3u
X81 a_4344_n400# OIB OI VSS nfet_03v3 ad=1.04p pd=4.52u as=1.04p ps=4.52u w=4u l=0.3u
X82 a_n708_n400# OQB OI VSS nfet_03v3 ad=1.04p pd=4.52u as=1.04p ps=4.52u w=4u l=0.3u
X83 VSS IBIAS a_n856_n400# VSS nfet_03v3 ad=1.04p pd=4.52u as=1.04p ps=4.52u w=4u l=1u
X84 a_n708_n400# CK a_n856_n400# VSS nfet_03v3 ad=1.04p pd=4.52u as=1.04p ps=4.52u w=4u l=0.3u
X85 VSS IBIAS a_n856_n7400# VSS nfet_03v3 ad=1.04p pd=4.52u as=1.04p ps=4.52u w=4u l=1u
X86 a_4344_n400# OI OIB VSS nfet_03v3 ad=1.04p pd=4.52u as=1.04p ps=4.52u w=4u l=0.3u
X87 a_n708_n7400# OI OQ VSS nfet_03v3 ad=1.04p pd=4.52u as=1.04p ps=4.52u w=4u l=0.3u
X88 a_n708_n7400# OIB OQB VSS nfet_03v3 ad=1.04p pd=4.52u as=1.04p ps=4.52u w=4u l=0.3u
X89 a_n708_n400# OQ OIB VSS nfet_03v3 ad=1.76p pd=8.88u as=1.04p ps=4.52u w=4u l=0.3u
X90 OI OIB a_4344_n400# VSS nfet_03v3 ad=1.04p pd=4.52u as=1.76p ps=8.88u w=4u l=0.3u
X91 VDD OIB VSS ppolyf_u_1k r_width=10u r_length=3u
X92 a_n708_n7400# OIB OQB VSS nfet_03v3 ad=1.04p pd=4.52u as=1.04p ps=4.52u w=4u l=0.3u
X93 OQB OIB a_n708_n7400# VSS nfet_03v3 ad=1.04p pd=4.52u as=1.04p ps=4.52u w=4u l=0.3u
X94 a_n856_n7400# IBIAS VSS VSS nfet_03v3 ad=1.04p pd=4.52u as=1.04p ps=4.52u w=4u l=1u
X95 a_n856_n400# IBIAS VSS VSS nfet_03v3 ad=1.04p pd=4.52u as=1.04p ps=4.52u w=4u l=1u
X96 a_n708_n7400# OI OQ VSS nfet_03v3 ad=1.04p pd=4.52u as=1.04p ps=4.52u w=4u l=0.3u
X97 OI OQB a_n708_n400# VSS nfet_03v3 ad=1.04p pd=4.52u as=1.04p ps=4.52u w=4u l=0.3u
X98 a_n708_n400# CK a_n856_n400# VSS nfet_03v3 ad=1.04p pd=4.52u as=1.76p ps=8.88u w=4u l=0.3u
X99 OQB OQ a_4344_n7400# VSS nfet_03v3 ad=1.04p pd=4.52u as=1.76p ps=8.88u w=4u l=0.3u
X100 VDD OQ VSS ppolyf_u_1k r_width=10u r_length=3u
X101 a_4344_n400# OIB OI VSS nfet_03v3 ad=1.76p pd=8.88u as=1.04p ps=4.52u w=4u l=0.3u
X102 VDD OI VSS ppolyf_u_1k r_width=10u r_length=3u
X103 a_n856_n400# CK a_n708_n400# VSS nfet_03v3 ad=1.04p pd=4.52u as=1.04p ps=4.52u w=4u l=0.3u
X104 OQB OIB a_n708_n7400# VSS nfet_03v3 ad=1.04p pd=4.52u as=1.04p ps=4.52u w=4u l=0.3u
X105 a_n708_n7400# OIB OQB VSS nfet_03v3 ad=1.76p pd=8.88u as=1.04p ps=4.52u w=4u l=0.3u
X106 OIB OQ a_n708_n400# VSS nfet_03v3 ad=1.04p pd=4.52u as=1.04p ps=4.52u w=4u l=0.3u
X107 a_n708_n400# OQB OI VSS nfet_03v3 ad=1.04p pd=4.52u as=1.04p ps=4.52u w=4u l=0.3u
X108 a_n856_n400# CK a_n708_n400# VSS nfet_03v3 ad=1.04p pd=4.52u as=1.04p ps=4.52u w=4u l=0.3u
X109 a_n708_n400# CK a_n856_n400# VSS nfet_03v3 ad=1.04p pd=4.52u as=1.04p ps=4.52u w=4u l=0.3u
X110 a_4344_n7400# CK a_n856_n7400# VSS nfet_03v3 ad=1.04p pd=4.52u as=1.04p ps=4.52u w=4u l=0.3u
X111 a_n708_n7400# CKB a_n856_n7400# VSS nfet_03v3 ad=1.04p pd=4.52u as=1.04p ps=4.52u w=4u l=0.3u
X112 a_4344_n400# OI OIB VSS nfet_03v3 ad=1.04p pd=4.52u as=1.04p ps=4.52u w=4u l=0.3u
X113 a_4344_n7400# OQB OQ VSS nfet_03v3 ad=1.04p pd=4.52u as=1.04p ps=4.52u w=4u l=0.3u
X114 a_n856_n7400# IBIAS VSS VSS nfet_03v3 ad=1.04p pd=4.52u as=1.76p ps=8.88u w=4u l=1u
X115 a_n708_n400# CK a_n856_n400# VSS nfet_03v3 ad=1.04p pd=4.52u as=1.04p ps=4.52u w=4u l=0.3u
X116 OIB OI a_4344_n400# VSS nfet_03v3 ad=1.04p pd=4.52u as=1.04p ps=4.52u w=4u l=0.3u
X117 OIB OI a_4344_n400# VSS nfet_03v3 ad=1.04p pd=4.52u as=1.04p ps=4.52u w=4u l=0.3u
X118 OQ OQB a_4344_n7400# VSS nfet_03v3 ad=1.04p pd=4.52u as=1.04p ps=4.52u w=4u l=0.3u
X119 a_n856_n400# IBIAS VSS VSS nfet_03v3 ad=1.04p pd=4.52u as=1.04p ps=4.52u w=4u l=1u
X120 a_n708_n7400# OI OQ VSS nfet_03v3 ad=1.04p pd=4.52u as=1.04p ps=4.52u w=4u l=0.3u
X121 OQ OI a_n708_n7400# VSS nfet_03v3 ad=1.04p pd=4.52u as=1.04p ps=4.52u w=4u l=0.3u
X122 a_n856_n7400# IBIAS VSS VSS nfet_03v3 ad=1.04p pd=4.52u as=1.04p ps=4.52u w=4u l=1u
X123 OQB OIB a_n708_n7400# VSS nfet_03v3 ad=1.04p pd=4.52u as=1.04p ps=4.52u w=4u l=0.3u
X124 a_4344_n7400# OQ OQB VSS nfet_03v3 ad=1.04p pd=4.52u as=1.04p ps=4.52u w=4u l=0.3u
X125 a_4344_n7400# CK a_n856_n7400# VSS nfet_03v3 ad=1.04p pd=4.52u as=1.76p ps=8.88u w=4u l=0.3u
X126 a_4344_n400# OI OIB VSS nfet_03v3 ad=1.04p pd=4.52u as=1.04p ps=4.52u w=4u l=0.3u
X127 VSS IBIAS a_n856_n7400# VSS nfet_03v3 ad=1.76p pd=8.88u as=1.04p ps=4.52u w=4u l=1u
X128 a_4344_n400# CKB a_n856_n400# VSS nfet_03v3 ad=1.04p pd=4.52u as=1.04p ps=4.52u w=4u l=0.3u
X129 OI OQB a_n708_n400# VSS nfet_03v3 ad=1.04p pd=4.52u as=1.04p ps=4.52u w=4u l=0.3u
X130 a_n708_n7400# CKB a_n856_n7400# VSS nfet_03v3 ad=1.04p pd=4.52u as=1.04p ps=4.52u w=4u l=0.3u
X131 a_n856_n7400# IBIAS VSS VSS nfet_03v3 ad=1.04p pd=4.52u as=1.04p ps=4.52u w=4u l=1u
X132 OQ OI a_n708_n7400# VSS nfet_03v3 ad=1.04p pd=4.52u as=1.04p ps=4.52u w=4u l=0.3u
X133 a_n708_n7400# CKB a_n856_n7400# VSS nfet_03v3 ad=1.04p pd=4.52u as=1.04p ps=4.52u w=4u l=0.3u
X134 VSS IBIAS a_n856_n400# VSS nfet_03v3 ad=1.04p pd=4.52u as=1.04p ps=4.52u w=4u l=1u
X135 a_n708_n7400# OI OQ VSS nfet_03v3 ad=1.76p pd=8.88u as=1.04p ps=4.52u w=4u l=0.3u
X136 a_n856_n400# CK a_n708_n400# VSS nfet_03v3 ad=1.04p pd=4.52u as=1.04p ps=4.52u w=4u l=0.3u
X137 a_n708_n400# OQ OIB VSS nfet_03v3 ad=1.04p pd=4.52u as=1.04p ps=4.52u w=4u l=0.3u
X138 a_4344_n7400# OQ OQB VSS nfet_03v3 ad=1.04p pd=4.52u as=1.04p ps=4.52u w=4u l=0.3u
X139 VSS IBIAS a_n856_n7400# VSS nfet_03v3 ad=1.04p pd=4.52u as=1.04p ps=4.52u w=4u l=1u
X140 a_n708_n400# OQB OI VSS nfet_03v3 ad=1.04p pd=4.52u as=1.04p ps=4.52u w=4u l=0.3u
X141 OQB OQ a_4344_n7400# VSS nfet_03v3 ad=1.04p pd=4.52u as=1.04p ps=4.52u w=4u l=0.3u
X142 OIB OI a_4344_n400# VSS nfet_03v3 ad=1.04p pd=4.52u as=1.76p ps=8.88u w=4u l=0.3u
X143 a_4344_n7400# OQ OQB VSS nfet_03v3 ad=1.04p pd=4.52u as=1.04p ps=4.52u w=4u l=0.3u
X144 OIB OQ a_n708_n400# VSS nfet_03v3 ad=1.04p pd=4.52u as=1.04p ps=4.52u w=4u l=0.3u
.ends

.subckt chip_top VTUNE I_N Q_P Q_N ISS VSSA VDDA IBIAS VDDD REF_IN CP_OUT
Xibias_gen_v1_0 IBIAS_uq0 CP_v1_0/VGP CP_v1_0/VGN DIV2_QUAD_v1_0/IBIAS VDDA VSSA ibias_gen_v1
XPFD_lib_0 CP_v1_0/DOWN I_P CP_v1_0/UP REF_IN VDDD VSSA PFD_lib
Xvco_v1_0 VTUNE VSSA VDDA ISS vco_v1_0/OUT_p vco_v1_0/OUT_n vco_v1
Xesd_rpoly_0 IBIAS_uq0 IBIAS VSSA esd_rpoly
Xesd_nd2ps_0 ISS ISS ISS ISS VSSA esd_nd2ps
Xesd_nd2ps_1 IBIAS_uq0 IBIAS_uq0 IBIAS_uq0 IBIAS_uq0 VSSA esd_nd2ps
Xesd_pd2nw_0 ISS ISS ISS VDDA ISS esd_pd2nw
Xesd_pd2nw_1 IBIAS_uq0 IBIAS_uq0 IBIAS_uq0 VDDA IBIAS_uq0 esd_pd2nw
XCP_v1_0 CP_v1_0/VGP CP_v1_0/VGN CP_v1_0/DOWN CP_OUT CP_v1_0/UP VDDA VSSA CP_v1
XDIV2_QUAD_v1_0 Q_P vco_v1_0/OUT_p vco_v1_0/OUT_n DIV2_QUAD_v1_0/IBIAS VSSA VDDD I_P
+ I_N Q_N DIV2_QUAD_v1
.ends
