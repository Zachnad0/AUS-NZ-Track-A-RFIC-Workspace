* NGSPICE file created from ibias_gen_v1.ext - technology: gf180mcuD

.subckt ibias_gen_v1 IBIAS VGP VGN IB_DIV2 VDD VSS
X0 a_17124_n400# a_n1372_556# VSS VSS nfet_03v3 ad=1.04p pd=4.52u as=1.04p ps=4.52u w=4u l=2u
X1 a_1396_12024# IBIAS a_17124_n400# VSS nfet_03v3 ad=1.04p pd=4.52u as=1.04p ps=4.52u w=4u l=1u
X2 IB_DIV2 a_17692_12024# a_17124_4400# VDD pfet_03v3 ad=4.16p pd=16.52u as=4.16p ps=16.52u w=16u l=1u
X3 a_196_7624# a_196_7624# VDD VDD pfet_03v3 ad=4.16p pd=16.52u as=4.16p ps=16.52u w=16u l=2u
X4 VDD a_196_7624# a_196_7624# VDD pfet_03v3 ad=7.04p pd=32.88u as=4.16p ps=16.52u w=16u l=2u
X5 IBIAS IBIAS a_n1372_556# VSS nfet_03v3 ad=1.04p pd=4.52u as=1.04p ps=4.52u w=4u l=1u
X6 a_1396_12024# IBIAS a_17124_n400# VSS nfet_03v3 ad=1.04p pd=4.52u as=1.04p ps=4.52u w=4u l=1u
X7 VDD a_196_7624# a_17124_4400# VDD pfet_03v3 ad=4.16p pd=16.52u as=4.16p ps=16.52u w=16u l=2u
X8 a_17124_4400# a_196_7624# VDD VDD pfet_03v3 ad=4.16p pd=16.52u as=4.16p ps=16.52u w=16u l=2u
X9 a_17124_4400# a_196_7624# VDD VDD pfet_03v3 ad=4.16p pd=16.52u as=4.16p ps=16.52u w=16u l=2u
X10 a_17124_4400# a_196_7624# VDD VDD pfet_03v3 ad=4.16p pd=16.52u as=4.16p ps=16.52u w=16u l=2u
X11 IB_DIV2 a_17692_12024# a_17124_4400# VDD pfet_03v3 ad=4.16p pd=16.52u as=4.16p ps=16.52u w=16u l=1u
X12 a_196_7624# a_196_7624# VDD VDD pfet_03v3 ad=4.16p pd=16.52u as=4.16p ps=16.52u w=16u l=2u
X13 VDD a_196_7624# a_14044_4400# VDD pfet_03v3 ad=4.16p pd=16.52u as=4.16p ps=16.52u w=16u l=2u
X14 VGP IBIAS a_7436_n400# VSS nfet_03v3 ad=1.04p pd=4.52u as=1.76p ps=8.88u w=4u l=1u
X15 a_14044_4400# a_196_7624# VDD VDD pfet_03v3 ad=7.04p pd=32.88u as=4.16p ps=16.52u w=16u l=2u
X16 a_17124_n400# a_n1372_556# VSS VSS nfet_03v3 ad=1.04p pd=4.52u as=1.04p ps=4.52u w=4u l=2u
X17 VSS a_n1372_556# a_17124_n400# VSS nfet_03v3 ad=1.04p pd=4.52u as=1.04p ps=4.52u w=4u l=2u
X18 a_17124_n400# IBIAS a_1396_12024# VSS nfet_03v3 ad=1.04p pd=4.52u as=1.04p ps=4.52u w=4u l=1u
X19 IB_DIV2 a_17692_12024# a_17124_4400# VDD pfet_03v3 ad=4.16p pd=16.52u as=4.16p ps=16.52u w=16u l=1u
X20 a_17124_n400# a_n1372_556# VSS VSS nfet_03v3 ad=1.04p pd=4.52u as=1.04p ps=4.52u w=4u l=2u
X21 VSS a_n1372_556# a_17124_n400# VSS nfet_03v3 ad=1.04p pd=4.52u as=1.04p ps=4.52u w=4u l=2u
X22 IBIAS IBIAS a_n1372_556# VSS nfet_03v3 ad=1.04p pd=4.52u as=1.04p ps=4.52u w=4u l=1u
X23 VSS a_n1372_556# a_17124_n400# VSS nfet_03v3 ad=1.04p pd=4.52u as=1.04p ps=4.52u w=4u l=2u
X24 a_17124_n400# a_n1372_556# VSS VSS nfet_03v3 ad=1.04p pd=4.52u as=1.04p ps=4.52u w=4u l=2u
X25 VSS a_n1372_556# a_n1372_556# VSS nfet_03v3 ad=1.04p pd=4.52u as=1.04p ps=4.52u w=4u l=2u
X26 a_1396_12024# a_1396_12024# a_196_7624# VDD pfet_03v3 ad=4.16p pd=16.52u as=4.16p ps=16.52u w=16u l=1u
X27 VDD a_196_7624# a_17124_4400# VDD pfet_03v3 ad=4.16p pd=16.52u as=4.16p ps=16.52u w=16u l=2u
X28 a_n1372_556# IBIAS IBIAS VSS nfet_03v3 ad=1.04p pd=4.52u as=1.04p ps=4.52u w=4u l=1u
X29 a_17124_4400# a_17692_12024# IB_DIV2 VDD pfet_03v3 ad=4.16p pd=16.52u as=4.16p ps=16.52u w=16u l=1u
X30 VDD a_196_7624# a_17124_4400# VDD pfet_03v3 ad=4.16p pd=16.52u as=4.16p ps=16.52u w=16u l=2u
X31 VSS a_n1372_556# VSS VSS nfet_03v3 ad=1.76p pd=8.88u as=74.88p ps=0.34144m w=4u l=2u
X32 IB_DIV2 a_17692_12024# a_17124_4400# VDD pfet_03v3 ad=4.16p pd=16.52u as=4.16p ps=16.52u w=16u l=1u
X33 a_17124_4400# a_196_7624# VDD VDD pfet_03v3 ad=4.16p pd=16.52u as=4.16p ps=16.52u w=16u l=2u
X34 IBIAS IBIAS a_n1372_556# VSS nfet_03v3 ad=1.04p pd=4.52u as=1.04p ps=4.52u w=4u l=1u
X35 VGP IBIAS a_7436_n400# VSS nfet_03v3 ad=1.04p pd=4.52u as=1.04p ps=4.52u w=4u l=1u
X36 a_1396_12024# a_1396_12024# a_196_7624# VDD pfet_03v3 ad=4.16p pd=16.52u as=4.16p ps=16.52u w=16u l=1u
X37 a_17124_4400# a_196_7624# VDD VDD pfet_03v3 ad=4.16p pd=16.52u as=4.16p ps=16.52u w=16u l=2u
X38 VSS a_n1372_556# VSS VSS nfet_03v3 ad=1.76p pd=8.88u as=0 ps=0 w=4u l=2u
X39 a_17124_n400# IBIAS a_1396_12024# VSS nfet_03v3 ad=1.04p pd=4.52u as=1.04p ps=4.52u w=4u l=1u
X40 a_17124_4400# a_17692_12024# IB_DIV2 VDD pfet_03v3 ad=7.04p pd=32.88u as=4.16p ps=16.52u w=16u l=1u
X41 a_n1372_556# IBIAS IBIAS VSS nfet_03v3 ad=1.04p pd=4.52u as=1.04p ps=4.52u w=4u l=1u
X42 VSS a_n1372_556# a_17124_n400# VSS nfet_03v3 ad=1.04p pd=4.52u as=1.04p ps=4.52u w=4u l=2u
X43 IBIAS IBIAS a_n1372_556# VSS nfet_03v3 ad=1.04p pd=4.52u as=1.04p ps=4.52u w=4u l=1u
X44 a_n1372_556# IBIAS IBIAS VSS nfet_03v3 ad=1.04p pd=4.52u as=1.04p ps=4.52u w=4u l=1u
X45 a_196_7624# a_1396_12024# a_1396_12024# VDD pfet_03v3 ad=4.16p pd=16.52u as=4.16p ps=16.52u w=16u l=1u
X46 a_1396_12024# a_1396_12024# a_196_7624# VDD pfet_03v3 ad=4.16p pd=16.52u as=4.16p ps=16.52u w=16u l=1u
X47 a_17124_n400# a_n1372_556# VSS VSS nfet_03v3 ad=1.04p pd=4.52u as=1.04p ps=4.52u w=4u l=2u
X48 VSS a_n1372_556# a_17124_n400# VSS nfet_03v3 ad=1.04p pd=4.52u as=1.04p ps=4.52u w=4u l=2u
X49 a_17124_n400# a_n1372_556# VSS VSS nfet_03v3 ad=1.04p pd=4.52u as=1.04p ps=4.52u w=4u l=2u
X50 VSS a_n1372_556# a_17124_n400# VSS nfet_03v3 ad=1.04p pd=4.52u as=1.04p ps=4.52u w=4u l=2u
X51 VSS a_n1372_556# a_n1372_556# VSS nfet_03v3 ad=1.04p pd=4.52u as=1.04p ps=4.52u w=4u l=2u
X52 a_n1372_556# a_n1372_556# VSS VSS nfet_03v3 ad=1.04p pd=4.52u as=1.04p ps=4.52u w=4u l=2u
X53 a_17124_n400# a_n1372_556# VSS VSS nfet_03v3 ad=1.04p pd=4.52u as=1.04p ps=4.52u w=4u l=2u
X54 VSS a_n1372_556# a_n1372_556# VSS nfet_03v3 ad=1.04p pd=4.52u as=1.04p ps=4.52u w=4u l=2u
X55 a_17124_n400# IBIAS a_1396_12024# VSS nfet_03v3 ad=1.04p pd=4.52u as=1.04p ps=4.52u w=4u l=1u
X56 VDD a_196_7624# a_17124_4400# VDD pfet_03v3 ad=4.16p pd=16.52u as=4.16p ps=16.52u w=16u l=2u
X57 IBIAS IBIAS a_n1372_556# VSS nfet_03v3 ad=1.04p pd=4.52u as=1.04p ps=4.52u w=4u l=1u
X58 a_1396_12024# a_1396_12024# a_196_7624# VDD pfet_03v3 ad=4.16p pd=16.52u as=4.16p ps=16.52u w=16u l=1u
X59 VDD a_196_7624# a_17124_4400# VDD pfet_03v3 ad=7.04p pd=32.88u as=4.16p ps=16.52u w=16u l=2u
X60 VDD a_196_7624# a_17124_4400# VDD pfet_03v3 ad=4.16p pd=16.52u as=4.16p ps=16.52u w=16u l=2u
X61 a_1396_12024# IBIAS a_17124_n400# VSS nfet_03v3 ad=1.04p pd=4.52u as=1.04p ps=4.52u w=4u l=1u
X62 VDD a_196_7624# a_196_7624# VDD pfet_03v3 ad=4.16p pd=16.52u as=4.16p ps=16.52u w=16u l=2u
X63 VDD a_196_7624# a_17124_4400# VDD pfet_03v3 ad=4.16p pd=16.52u as=4.16p ps=16.52u w=16u l=2u
X64 a_n1372_556# IBIAS IBIAS VSS nfet_03v3 ad=1.04p pd=4.52u as=1.04p ps=4.52u w=4u l=1u
X65 VSS a_n1372_556# a_17124_n400# VSS nfet_03v3 ad=1.76p pd=8.88u as=1.04p ps=4.52u w=4u l=2u
X66 a_17124_4400# a_17692_12024# IB_DIV2 VDD pfet_03v3 ad=4.16p pd=16.52u as=4.16p ps=16.52u w=16u l=1u
X67 a_1396_12024# IBIAS a_17124_n400# VSS nfet_03v3 ad=1.04p pd=4.52u as=1.04p ps=4.52u w=4u l=1u
X68 VDD a_196_7624# VDD VDD pfet_03v3 ad=4.16p pd=16.52u as=0.31616n ps=1.31952m w=16u l=2u
X69 VSS a_n1372_556# a_17124_n400# VSS nfet_03v3 ad=1.04p pd=4.52u as=1.04p ps=4.52u w=4u l=2u
X70 a_1396_12024# a_1396_12024# a_196_7624# VDD pfet_03v3 ad=4.16p pd=16.52u as=7.04p ps=32.88u w=16u l=1u
X71 VSS a_n1372_556# a_17124_n400# VSS nfet_03v3 ad=1.04p pd=4.52u as=1.04p ps=4.52u w=4u l=2u
X72 a_1396_12024# IBIAS a_17124_n400# VSS nfet_03v3 ad=1.04p pd=4.52u as=1.04p ps=4.52u w=4u l=1u
X73 a_1396_12024# IBIAS a_17124_n400# VSS nfet_03v3 ad=1.04p pd=4.52u as=1.04p ps=4.52u w=4u l=1u
X74 a_17124_n400# IBIAS a_1396_12024# VSS nfet_03v3 ad=1.04p pd=4.52u as=1.04p ps=4.52u w=4u l=1u
X75 a_17124_4400# a_196_7624# VDD VDD pfet_03v3 ad=4.16p pd=16.52u as=4.16p ps=16.52u w=16u l=2u
X76 a_n1372_556# a_n1372_556# VSS VSS nfet_03v3 ad=1.04p pd=4.52u as=1.04p ps=4.52u w=4u l=2u
X77 VGN a_1396_12024# a_14044_4400# VDD pfet_03v3 ad=4.16p pd=16.52u as=4.16p ps=16.52u w=16u l=1u
X78 VDD a_196_7624# a_17124_4400# VDD pfet_03v3 ad=4.16p pd=16.52u as=4.16p ps=16.52u w=16u l=2u
X79 a_n1372_556# IBIAS IBIAS VSS nfet_03v3 ad=1.04p pd=4.52u as=1.04p ps=4.52u w=4u l=1u
X80 VSS a_n1372_556# a_n1372_556# VSS nfet_03v3 ad=1.04p pd=4.52u as=1.04p ps=4.52u w=4u l=2u
X81 a_1396_12024# a_1396_12024# a_196_7624# VDD pfet_03v3 ad=4.16p pd=16.52u as=4.16p ps=16.52u w=16u l=1u
X82 a_196_7624# a_1396_12024# a_1396_12024# VDD pfet_03v3 ad=7.04p pd=32.88u as=4.16p ps=16.52u w=16u l=1u
X83 a_17124_4400# a_196_7624# VDD VDD pfet_03v3 ad=4.16p pd=16.52u as=7.04p ps=32.88u w=16u l=2u
X84 VSS a_n1372_556# VSS VSS nfet_03v3 ad=1.04p pd=4.52u as=0 ps=0 w=4u l=2u
X85 a_33292_7624# a_17692_12024# a_17692_12024# VDD pfet_03v3 ad=7.04p pd=32.88u as=4.16p ps=16.52u w=16u l=1u
X86 VDD a_196_7624# a_17124_4400# VDD pfet_03v3 ad=4.16p pd=16.52u as=4.16p ps=16.52u w=16u l=2u
X87 a_196_7624# a_1396_12024# a_1396_12024# VDD pfet_03v3 ad=4.16p pd=16.52u as=4.16p ps=16.52u w=16u l=1u
X88 a_17124_4400# a_17692_12024# IB_DIV2 VDD pfet_03v3 ad=4.16p pd=16.52u as=4.16p ps=16.52u w=16u l=1u
X89 IB_DIV2 a_17692_12024# a_17124_4400# VDD pfet_03v3 ad=4.16p pd=16.52u as=4.16p ps=16.52u w=16u l=1u
X90 a_196_7624# a_196_7624# VDD VDD pfet_03v3 ad=4.16p pd=16.52u as=4.16p ps=16.52u w=16u l=2u
X91 VDD a_196_7624# a_17124_4400# VDD pfet_03v3 ad=4.16p pd=16.52u as=4.16p ps=16.52u w=16u l=2u
X92 a_17124_4400# a_17692_12024# IB_DIV2 VDD pfet_03v3 ad=4.16p pd=16.52u as=4.16p ps=16.52u w=16u l=1u
X93 IB_DIV2 a_17692_12024# a_17124_4400# VDD pfet_03v3 ad=4.16p pd=16.52u as=7.04p ps=32.88u w=16u l=1u
X94 VDD a_196_7624# a_196_7624# VDD pfet_03v3 ad=4.16p pd=16.52u as=4.16p ps=16.52u w=16u l=2u
X95 a_17124_n400# IBIAS a_1396_12024# VSS nfet_03v3 ad=1.04p pd=4.52u as=1.04p ps=4.52u w=4u l=1u
X96 IBIAS IBIAS a_n1372_556# VSS nfet_03v3 ad=1.04p pd=4.52u as=1.76p ps=8.88u w=4u l=1u
X97 a_7436_n400# IBIAS VGP VSS nfet_03v3 ad=1.04p pd=4.52u as=1.04p ps=4.52u w=4u l=1u
X98 a_1396_12024# a_1396_12024# a_196_7624# VDD pfet_03v3 ad=4.16p pd=16.52u as=4.16p ps=16.52u w=16u l=1u
X99 VDD a_196_7624# a_196_7624# VDD pfet_03v3 ad=4.16p pd=16.52u as=4.16p ps=16.52u w=16u l=2u
X100 VSS a_n1372_556# a_17692_12024# VSS nfet_03v3 ad=1.76p pd=8.88u as=1.04p ps=4.52u w=4u l=2u
X101 a_17124_4400# a_17692_12024# IB_DIV2 VDD pfet_03v3 ad=4.16p pd=16.52u as=4.16p ps=16.52u w=16u l=1u
X102 VSS a_n1372_556# a_n1372_556# VSS nfet_03v3 ad=1.04p pd=4.52u as=1.04p ps=4.52u w=4u l=2u
X103 a_1396_12024# IBIAS a_17124_n400# VSS nfet_03v3 ad=1.04p pd=4.52u as=1.04p ps=4.52u w=4u l=1u
X104 VGN a_1396_12024# a_14044_4400# VDD pfet_03v3 ad=7.04p pd=32.88u as=4.16p ps=16.52u w=16u l=1u
X105 a_n1372_556# IBIAS IBIAS VSS nfet_03v3 ad=1.04p pd=4.52u as=1.04p ps=4.52u w=4u l=1u
X106 VDD a_196_7624# VDD VDD pfet_03v3 ad=4.16p pd=16.52u as=0 ps=0 w=16u l=2u
X107 a_n1372_556# IBIAS IBIAS VSS nfet_03v3 ad=1.04p pd=4.52u as=1.04p ps=4.52u w=4u l=1u
X108 VSS a_n1372_556# a_17124_n400# VSS nfet_03v3 ad=1.04p pd=4.52u as=1.04p ps=4.52u w=4u l=2u
X109 a_n1372_556# a_n1372_556# VSS VSS nfet_03v3 ad=1.04p pd=4.52u as=1.04p ps=4.52u w=4u l=2u
X110 a_17124_4400# a_196_7624# VDD VDD pfet_03v3 ad=4.16p pd=16.52u as=4.16p ps=16.52u w=16u l=2u
X111 VSS a_n1372_556# a_n1372_556# VSS nfet_03v3 ad=1.76p pd=8.88u as=1.04p ps=4.52u w=4u l=2u
X112 a_n1372_556# a_n1372_556# VSS VSS nfet_03v3 ad=1.04p pd=4.52u as=1.04p ps=4.52u w=4u l=2u
X113 a_n1372_556# a_n1372_556# VSS VSS nfet_03v3 ad=1.04p pd=4.52u as=1.76p ps=8.88u w=4u l=2u
X114 VDD a_196_7624# a_17124_4400# VDD pfet_03v3 ad=7.04p pd=32.88u as=4.16p ps=16.52u w=16u l=2u
X115 a_17124_4400# a_196_7624# VDD VDD pfet_03v3 ad=4.16p pd=16.52u as=4.16p ps=16.52u w=16u l=2u
X116 VDD a_196_7624# a_17124_4400# VDD pfet_03v3 ad=4.16p pd=16.52u as=4.16p ps=16.52u w=16u l=2u
X117 VSS a_n1372_556# a_n1372_556# VSS nfet_03v3 ad=1.04p pd=4.52u as=1.04p ps=4.52u w=4u l=2u
X118 IB_DIV2 a_17692_12024# a_17124_4400# VDD pfet_03v3 ad=4.16p pd=16.52u as=4.16p ps=16.52u w=16u l=1u
X119 VSS a_n1372_556# VSS VSS nfet_03v3 ad=1.04p pd=4.52u as=0 ps=0 w=4u l=2u
X120 a_196_7624# a_1396_12024# a_1396_12024# VDD pfet_03v3 ad=4.16p pd=16.52u as=4.16p ps=16.52u w=16u l=1u
X121 a_196_7624# a_196_7624# VDD VDD pfet_03v3 ad=4.16p pd=16.52u as=4.16p ps=16.52u w=16u l=2u
X122 VDD a_196_7624# a_196_7624# VDD pfet_03v3 ad=4.16p pd=16.52u as=4.16p ps=16.52u w=16u l=2u
X123 a_17124_n400# IBIAS a_1396_12024# VSS nfet_03v3 ad=1.04p pd=4.52u as=1.04p ps=4.52u w=4u l=1u
X124 VSS a_n1372_556# a_7436_n400# VSS nfet_03v3 ad=1.04p pd=4.52u as=1.04p ps=4.52u w=4u l=2u
X125 IBIAS IBIAS a_n1372_556# VSS nfet_03v3 ad=1.04p pd=4.52u as=1.04p ps=4.52u w=4u l=1u
X126 VSS a_n1372_556# a_n1372_556# VSS nfet_03v3 ad=1.04p pd=4.52u as=1.04p ps=4.52u w=4u l=2u
X127 a_n1372_556# a_n1372_556# VSS VSS nfet_03v3 ad=1.04p pd=4.52u as=1.76p ps=8.88u w=4u l=2u
X128 a_17124_n400# IBIAS a_1396_12024# VSS nfet_03v3 ad=1.04p pd=4.52u as=1.04p ps=4.52u w=4u l=1u
X129 a_17124_4400# a_17692_12024# IB_DIV2 VDD pfet_03v3 ad=4.16p pd=16.52u as=4.16p ps=16.52u w=16u l=1u
X130 VDD a_196_7624# VDD VDD pfet_03v3 ad=4.16p pd=16.52u as=0 ps=0 w=16u l=2u
X131 VSS a_n1372_556# a_n1372_556# VSS nfet_03v3 ad=1.04p pd=4.52u as=1.04p ps=4.52u w=4u l=2u
X132 VDD a_196_7624# VDD VDD pfet_03v3 ad=7.04p pd=32.88u as=0 ps=0 w=16u l=2u
X133 a_1396_12024# IBIAS a_17124_n400# VSS nfet_03v3 ad=1.04p pd=4.52u as=1.76p ps=8.88u w=4u l=1u
X134 a_7436_n400# IBIAS VGP VSS nfet_03v3 ad=1.04p pd=4.52u as=1.04p ps=4.52u w=4u l=1u
X135 a_n1372_556# a_n1372_556# VSS VSS nfet_03v3 ad=1.04p pd=4.52u as=1.04p ps=4.52u w=4u l=2u
X136 VGN a_1396_12024# a_14044_4400# VDD pfet_03v3 ad=4.16p pd=16.52u as=7.04p ps=32.88u w=16u l=1u
X137 a_17124_4400# a_196_7624# VDD VDD pfet_03v3 ad=4.16p pd=16.52u as=4.16p ps=16.52u w=16u l=2u
X138 a_17124_4400# a_17692_12024# IB_DIV2 VDD pfet_03v3 ad=4.16p pd=16.52u as=4.16p ps=16.52u w=16u l=1u
X139 a_n1372_556# IBIAS IBIAS VSS nfet_03v3 ad=1.04p pd=4.52u as=1.04p ps=4.52u w=4u l=1u
X140 a_196_7624# a_1396_12024# a_1396_12024# VDD pfet_03v3 ad=4.16p pd=16.52u as=4.16p ps=16.52u w=16u l=1u
X141 a_17124_n400# IBIAS a_1396_12024# VSS nfet_03v3 ad=1.76p pd=8.88u as=1.04p ps=4.52u w=4u l=1u
X142 a_1396_12024# a_1396_12024# a_196_7624# VDD pfet_03v3 ad=4.16p pd=16.52u as=4.16p ps=16.52u w=16u l=1u
X143 a_1396_12024# a_1396_12024# a_196_7624# VDD pfet_03v3 ad=4.16p pd=16.52u as=4.16p ps=16.52u w=16u l=1u
X144 a_196_7624# a_1396_12024# a_1396_12024# VDD pfet_03v3 ad=4.16p pd=16.52u as=4.16p ps=16.52u w=16u l=1u
X145 a_196_7624# a_196_7624# VDD VDD pfet_03v3 ad=4.16p pd=16.52u as=4.16p ps=16.52u w=16u l=2u
X146 IBIAS IBIAS a_n1372_556# VSS nfet_03v3 ad=1.04p pd=4.52u as=1.04p ps=4.52u w=4u l=1u
X147 IB_DIV2 a_17692_12024# a_17124_4400# VDD pfet_03v3 ad=4.16p pd=16.52u as=4.16p ps=16.52u w=16u l=1u
X148 a_196_7624# a_196_7624# VDD VDD pfet_03v3 ad=4.16p pd=16.52u as=7.04p ps=32.88u w=16u l=2u
X149 a_196_7624# a_196_7624# VDD VDD pfet_03v3 ad=4.16p pd=16.52u as=4.16p ps=16.52u w=16u l=2u
X150 a_33292_7624# a_33292_7624# VDD VDD pfet_03v3 ad=4.16p pd=16.52u as=7.04p ps=32.88u w=16u l=2u
X151 VDD a_196_7624# a_196_7624# VDD pfet_03v3 ad=7.04p pd=32.88u as=4.16p ps=16.52u w=16u l=2u
X152 a_7436_n400# a_n1372_556# VSS VSS nfet_03v3 ad=1.04p pd=4.52u as=1.76p ps=8.88u w=4u l=2u
X153 a_17124_n400# IBIAS a_1396_12024# VSS nfet_03v3 ad=1.04p pd=4.52u as=1.04p ps=4.52u w=4u l=1u
X154 IB_DIV2 a_17692_12024# a_17124_4400# VDD pfet_03v3 ad=4.16p pd=16.52u as=4.16p ps=16.52u w=16u l=1u
X155 a_17124_4400# a_17692_12024# IB_DIV2 VDD pfet_03v3 ad=4.16p pd=16.52u as=4.16p ps=16.52u w=16u l=1u
X156 a_17692_12024# a_n1372_556# VSS VSS nfet_03v3 ad=1.04p pd=4.52u as=1.76p ps=8.88u w=4u l=2u
X157 VDD a_196_7624# a_196_7624# VDD pfet_03v3 ad=4.16p pd=16.52u as=4.16p ps=16.52u w=16u l=2u
X158 IBIAS IBIAS a_n1372_556# VSS nfet_03v3 ad=1.04p pd=4.52u as=1.04p ps=4.52u w=4u l=1u
X159 a_n1372_556# a_n1372_556# VSS VSS nfet_03v3 ad=1.04p pd=4.52u as=1.04p ps=4.52u w=4u l=2u
X160 a_n1372_556# IBIAS IBIAS VSS nfet_03v3 ad=1.04p pd=4.52u as=1.04p ps=4.52u w=4u l=1u
X161 VSS a_n1372_556# a_n1372_556# VSS nfet_03v3 ad=1.04p pd=4.52u as=1.04p ps=4.52u w=4u l=2u
X162 VSS a_n1372_556# a_7436_n400# VSS nfet_03v3 ad=1.04p pd=4.52u as=1.04p ps=4.52u w=4u l=2u
X163 VDD a_196_7624# VDD VDD pfet_03v3 ad=4.16p pd=16.52u as=0 ps=0 w=16u l=2u
X164 a_17124_n400# IBIAS a_1396_12024# VSS nfet_03v3 ad=1.04p pd=4.52u as=1.04p ps=4.52u w=4u l=1u
X165 IBIAS IBIAS a_n1372_556# VSS nfet_03v3 ad=1.04p pd=4.52u as=1.04p ps=4.52u w=4u l=1u
X166 VDD a_196_7624# a_196_7624# VDD pfet_03v3 ad=4.16p pd=16.52u as=4.16p ps=16.52u w=16u l=2u
X167 a_17124_4400# a_196_7624# VDD VDD pfet_03v3 ad=4.16p pd=16.52u as=4.16p ps=16.52u w=16u l=2u
X168 a_1396_12024# a_1396_12024# a_196_7624# VDD pfet_03v3 ad=4.16p pd=16.52u as=4.16p ps=16.52u w=16u l=1u
X169 a_196_7624# a_1396_12024# a_1396_12024# VDD pfet_03v3 ad=7.04p pd=32.88u as=4.16p ps=16.52u w=16u l=1u
X170 VDD a_33292_7624# a_33292_7624# VDD pfet_03v3 ad=7.04p pd=32.88u as=4.16p ps=16.52u w=16u l=2u
X171 a_17124_4400# a_17692_12024# IB_DIV2 VDD pfet_03v3 ad=4.16p pd=16.52u as=4.16p ps=16.52u w=16u l=1u
X172 a_17124_n400# a_n1372_556# VSS VSS nfet_03v3 ad=1.04p pd=4.52u as=1.76p ps=8.88u w=4u l=2u
X173 a_1396_12024# IBIAS a_17124_n400# VSS nfet_03v3 ad=1.04p pd=4.52u as=1.04p ps=4.52u w=4u l=1u
X174 a_196_7624# a_1396_12024# a_1396_12024# VDD pfet_03v3 ad=4.16p pd=16.52u as=4.16p ps=16.52u w=16u l=1u
X175 a_196_7624# a_196_7624# VDD VDD pfet_03v3 ad=4.16p pd=16.52u as=4.16p ps=16.52u w=16u l=2u
X176 VDD a_196_7624# a_196_7624# VDD pfet_03v3 ad=4.16p pd=16.52u as=4.16p ps=16.52u w=16u l=2u
X177 a_n1372_556# IBIAS IBIAS VSS nfet_03v3 ad=1.04p pd=4.52u as=1.04p ps=4.52u w=4u l=1u
X178 a_n1372_556# a_n1372_556# VSS VSS nfet_03v3 ad=1.04p pd=4.52u as=1.04p ps=4.52u w=4u l=2u
X179 a_7436_n400# a_n1372_556# VSS VSS nfet_03v3 ad=1.04p pd=4.52u as=1.04p ps=4.52u w=4u l=2u
X180 a_17692_12024# a_17692_12024# a_33292_7624# VDD pfet_03v3 ad=4.16p pd=16.52u as=7.04p ps=32.88u w=16u l=1u
X181 VSS a_n1372_556# a_n1372_556# VSS nfet_03v3 ad=1.04p pd=4.52u as=1.04p ps=4.52u w=4u l=2u
X182 a_n1372_556# a_n1372_556# VSS VSS nfet_03v3 ad=1.04p pd=4.52u as=1.04p ps=4.52u w=4u l=2u
X183 IBIAS IBIAS a_n1372_556# VSS nfet_03v3 ad=1.04p pd=4.52u as=1.04p ps=4.52u w=4u l=1u
X184 VDD a_196_7624# VDD VDD pfet_03v3 ad=4.16p pd=16.52u as=0 ps=0 w=16u l=2u
X185 a_1396_12024# IBIAS a_17124_n400# VSS nfet_03v3 ad=1.04p pd=4.52u as=1.04p ps=4.52u w=4u l=1u
X186 a_17124_n400# IBIAS a_1396_12024# VSS nfet_03v3 ad=1.04p pd=4.52u as=1.04p ps=4.52u w=4u l=1u
X187 a_17124_n400# IBIAS a_1396_12024# VSS nfet_03v3 ad=1.04p pd=4.52u as=1.04p ps=4.52u w=4u l=1u
X188 a_196_7624# a_1396_12024# a_1396_12024# VDD pfet_03v3 ad=4.16p pd=16.52u as=4.16p ps=16.52u w=16u l=1u
X189 a_196_7624# a_196_7624# VDD VDD pfet_03v3 ad=4.16p pd=16.52u as=7.04p ps=32.88u w=16u l=2u
X190 VDD a_196_7624# a_196_7624# VDD pfet_03v3 ad=4.16p pd=16.52u as=4.16p ps=16.52u w=16u l=2u
X191 a_14044_4400# a_1396_12024# VGN VDD pfet_03v3 ad=4.16p pd=16.52u as=4.16p ps=16.52u w=16u l=1u
X192 a_17124_4400# a_17692_12024# IB_DIV2 VDD pfet_03v3 ad=4.16p pd=16.52u as=4.16p ps=16.52u w=16u l=1u
X193 IB_DIV2 a_17692_12024# a_17124_4400# VDD pfet_03v3 ad=4.16p pd=16.52u as=4.16p ps=16.52u w=16u l=1u
X194 VDD a_196_7624# a_196_7624# VDD pfet_03v3 ad=4.16p pd=16.52u as=4.16p ps=16.52u w=16u l=2u
X195 a_14044_4400# a_196_7624# VDD VDD pfet_03v3 ad=4.16p pd=16.52u as=7.04p ps=32.88u w=16u l=2u
X196 a_1396_12024# IBIAS a_17124_n400# VSS nfet_03v3 ad=1.04p pd=4.52u as=1.04p ps=4.52u w=4u l=1u
X197 a_1396_12024# a_1396_12024# a_196_7624# VDD pfet_03v3 ad=4.16p pd=16.52u as=4.16p ps=16.52u w=16u l=1u
X198 VSS a_n1372_556# a_17124_n400# VSS nfet_03v3 ad=1.04p pd=4.52u as=1.04p ps=4.52u w=4u l=2u
X199 a_17124_n400# a_n1372_556# VSS VSS nfet_03v3 ad=1.04p pd=4.52u as=1.04p ps=4.52u w=4u l=2u
X200 a_196_7624# a_196_7624# VDD VDD pfet_03v3 ad=4.16p pd=16.52u as=4.16p ps=16.52u w=16u l=2u
X201 a_17124_n400# a_n1372_556# VSS VSS nfet_03v3 ad=1.04p pd=4.52u as=1.04p ps=4.52u w=4u l=2u
X202 a_1396_12024# a_1396_12024# a_196_7624# VDD pfet_03v3 ad=4.16p pd=16.52u as=7.04p ps=32.88u w=16u l=1u
X203 a_196_7624# a_1396_12024# a_1396_12024# VDD pfet_03v3 ad=4.16p pd=16.52u as=4.16p ps=16.52u w=16u l=1u
X204 a_17124_n400# a_n1372_556# VSS VSS nfet_03v3 ad=1.04p pd=4.52u as=1.04p ps=4.52u w=4u l=2u
X205 VDD a_196_7624# a_196_7624# VDD pfet_03v3 ad=4.16p pd=16.52u as=4.16p ps=16.52u w=16u l=2u
X206 a_n1372_556# IBIAS IBIAS VSS nfet_03v3 ad=1.76p pd=8.88u as=1.04p ps=4.52u w=4u l=1u
X207 a_n1372_556# a_n1372_556# VSS VSS nfet_03v3 ad=1.04p pd=4.52u as=1.04p ps=4.52u w=4u l=2u
X208 a_7436_n400# a_n1372_556# VSS VSS nfet_03v3 ad=1.76p pd=8.88u as=1.04p ps=4.52u w=4u l=2u
X209 a_1396_12024# IBIAS a_17124_n400# VSS nfet_03v3 ad=1.04p pd=4.52u as=1.04p ps=4.52u w=4u l=1u
X210 a_n1372_556# a_n1372_556# VSS VSS nfet_03v3 ad=1.04p pd=4.52u as=1.04p ps=4.52u w=4u l=2u
X211 a_n1372_556# IBIAS IBIAS VSS nfet_03v3 ad=1.04p pd=4.52u as=1.04p ps=4.52u w=4u l=1u
X212 VSS a_n1372_556# a_n1372_556# VSS nfet_03v3 ad=1.76p pd=8.88u as=1.04p ps=4.52u w=4u l=2u
X213 a_196_7624# a_1396_12024# a_1396_12024# VDD pfet_03v3 ad=4.16p pd=16.52u as=4.16p ps=16.52u w=16u l=1u
X214 VGP IBIAS a_7436_n400# VSS nfet_03v3 ad=1.76p pd=8.88u as=1.04p ps=4.52u w=4u l=1u
X215 a_17124_4400# a_196_7624# VDD VDD pfet_03v3 ad=4.16p pd=16.52u as=7.04p ps=32.88u w=16u l=2u
X216 a_14044_4400# a_1396_12024# VGN VDD pfet_03v3 ad=4.16p pd=16.52u as=4.16p ps=16.52u w=16u l=1u
X217 IB_DIV2 a_17692_12024# a_17124_4400# VDD pfet_03v3 ad=4.16p pd=16.52u as=4.16p ps=16.52u w=16u l=1u
X218 IBIAS IBIAS a_n1372_556# VSS nfet_03v3 ad=1.04p pd=4.52u as=1.04p ps=4.52u w=4u l=1u
X219 a_196_7624# a_196_7624# VDD VDD pfet_03v3 ad=4.16p pd=16.52u as=4.16p ps=16.52u w=16u l=2u
X220 VDD a_196_7624# a_14044_4400# VDD pfet_03v3 ad=4.16p pd=16.52u as=4.16p ps=16.52u w=16u l=2u
X221 a_196_7624# a_1396_12024# a_1396_12024# VDD pfet_03v3 ad=4.16p pd=16.52u as=4.16p ps=16.52u w=16u l=1u
X222 a_14044_4400# a_196_7624# VDD VDD pfet_03v3 ad=4.16p pd=16.52u as=4.16p ps=16.52u w=16u l=2u
X223 IB_DIV2 a_17692_12024# a_17124_4400# VDD pfet_03v3 ad=4.16p pd=16.52u as=7.04p ps=32.88u w=16u l=1u
X224 a_17124_4400# a_17692_12024# IB_DIV2 VDD pfet_03v3 ad=7.04p pd=32.88u as=4.16p ps=16.52u w=16u l=1u
X225 VSS a_n1372_556# a_17124_n400# VSS nfet_03v3 ad=1.04p pd=4.52u as=1.04p ps=4.52u w=4u l=2u
X226 a_196_7624# a_196_7624# VDD VDD pfet_03v3 ad=4.16p pd=16.52u as=4.16p ps=16.52u w=16u l=2u
X227 a_17124_n400# a_n1372_556# VSS VSS nfet_03v3 ad=1.04p pd=4.52u as=1.04p ps=4.52u w=4u l=2u
.ends
