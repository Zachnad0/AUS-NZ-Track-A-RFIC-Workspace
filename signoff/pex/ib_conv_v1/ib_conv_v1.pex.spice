* NGSPICE file created from ib_conv_v1_flat.ext - technology: gf180mcuD

X0 a_938_3424.t2 INP.t0 a_100_n800.t2 VSS.t11 nfet_03v3 ad=3.52p pd=16.88u as=3.52p ps=16.88u w=8u l=0.3u
X1 a_938_3424.t1 a_938_3424.t0 VDD.t1 VDD.t0 pfet_03v3 ad=3.52p pd=16.88u as=3.52p ps=16.88u w=8u l=0.3u
X2 a_8030_n1600.t0 a_6430_n1100.t3 VDD.t5 VDD.t4 pfet_03v3 ad=19.36p pd=88.88u as=19.36p ps=88.88u w=44u l=0.3u
X3 a_8030_n1600.t2 a_6430_n1100.t2 VSS.t10 VSS.t9 nfet_03v3 ad=7.04p pd=32.88u as=7.04p ps=32.88u w=16u l=0.3u
X4 a_6430_n1100.t0 a_2156_7176.t4 VDD.t3 VDD.t2 pfet_03v3 ad=11.44p pd=52.88u as=11.44p ps=52.88u w=26u l=0.3u
X5 a_2430_n800.t1 INM.t0 a_100_n800.t0 VSS.t0 nfet_03v3 ad=3.52p pd=16.88u as=3.52p ps=16.88u w=8u l=0.3u
X6 a_6430_n1100.t1 a_2156_7176.t3 VSS.t7 VSS.t6 nfet_03v3 ad=4.84p pd=22.88u as=4.84p ps=22.88u w=11u l=0.3u
X7 OUT.t0 a_8030_n1600.t1 VSS.t8 ppolyf_u_1k r_width=2u r_length=2u
X8 a_2156_7176.t1 a_1676_7176.t2 VSS.t2 VSS.t1 nfet_03v3 ad=1.76p pd=8.88u as=1.76p ps=8.88u w=4u l=0.3u
X9 a_100_n800.t1 IBIAS.t0 VSS.t5 VSS.t4 nfet_03v3 ad=3.52p pd=16.88u as=3.52p ps=16.88u w=8u l=1u
X10 a_2156_7176.t0 a_1676_7176.t3 VDD.t9 VDD.t8 pfet_03v3 ad=4.4p pd=20.88u as=4.4p ps=20.88u w=10u l=0.3u
X11 a_2430_n800.t0 a_938_3424.t3 VDD.t7 VDD.t6 pfet_03v3 ad=3.52p pd=16.88u as=3.52p ps=16.88u w=8u l=0.3u
X12 a_2430_n800.t2 a_1676_7176.t1 cap_mim_2f0_m4m5_noshield c_width=5u c_length=10u
X13 a_2156_7176.t2 a_1676_7176.t0 VSS.t3 ppolyf_u_1k r_width=2u r_length=40.04u
C0 INM INP 0.0187f
C1 INP VDD 0.03938f
C2 m1_3129_7189# VDD 0.00196f
C3 OUT VDD 0.0071f
C4 INM VDD 0.03938f
C5 IBIAS INP 0.01831f
C6 IBIAS VDD 0.05655f
R0 INM INM.t0 163.077
R1 INP INP.t0 163.077
R2 IBIAS IBIAS.t0 79.7738
R3 OUT OUT.t0 3.62478
R4 VDD.n0 VDD.t4 4010.79
R5 VDD.n1 VDD.t2 2510.79
R6 VDD.n3 VDD.t8 1177.45
R7 VDD.t0 VDD.t6 468.75
R8 VDD.n0 VDD.t5 41.935
R9 VDD.n1 VDD.t3 32.6948
R10 VDD.n3 VDD.t9 24.6866
R11 VDD.n6 VDD.n5 17.1101
R12 VDD.n2 VDD.n0 14.4605
R13 VDD.n2 VDD.n1 10.2755
R14 VDD.n4 VDD.n3 9.0755
R15 VDD.n5 VDD.t7 8.25479
R16 VDD.n5 VDD.t1 6.32622
R17 VDD VDD.n6 5.89737
R18 VDD.n4 VDD.n2 2.8355
R19 VDD VDD.n4 1.6835
R20 VDD.n6 VDD.t0 0.546648
R21 VSS.t4 VSS.n166 22187.7
R22 VSS.n165 VSS.n164 18727.5
R23 VSS.n164 VSS.t8 7638.22
R24 VSS.n169 VSS.n166 4092.47
R25 VSS.n164 VSS.n163 1140.34
R26 VSS.t0 VSS.t11 975
R27 VSS.t11 VSS.t4 975
R28 VSS.n169 VSS.t0 965.927
R29 VSS.t1 VSS.t6 834.404
R30 VSS.n163 VSS.t6 576.782
R31 VSS.t1 VSS.n169 547.577
R32 VSS.n163 VSS.t9 257.623
R33 VSS.n165 VSS.t3 74.9027
R34 VSS.n166 VSS.n165 35.4476
R35 VSS.n20 VSS.t5 11.753
R36 VSS.n97 VSS.t10 4.53915
R37 VSS.n162 VSS.n161 4.52338
R38 VSS.n143 VSS.n142 4.5005
R39 VSS.n144 VSS.n103 4.5005
R40 VSS.n146 VSS.n145 4.5005
R41 VSS.n147 VSS.n102 4.5005
R42 VSS.n149 VSS.n148 4.5005
R43 VSS.n150 VSS.n101 4.5005
R44 VSS.n152 VSS.n151 4.5005
R45 VSS.n153 VSS.n100 4.5005
R46 VSS.n155 VSS.n154 4.5005
R47 VSS.n156 VSS.n99 4.5005
R48 VSS.n158 VSS.n157 4.5005
R49 VSS.n159 VSS.n98 4.5005
R50 VSS.n161 VSS.n160 4.5005
R51 VSS.n121 VSS.n95 4.5005
R52 VSS.n123 VSS.n122 4.5005
R53 VSS.n120 VSS.n119 4.5005
R54 VSS.n127 VSS.n118 4.5005
R55 VSS.n128 VSS.n117 4.5005
R56 VSS.n129 VSS.n116 4.5005
R57 VSS.n115 VSS.n113 4.5005
R58 VSS.n133 VSS.n112 4.5005
R59 VSS.n134 VSS.n111 4.5005
R60 VSS.n135 VSS.n110 4.5005
R61 VSS.n106 VSS.n105 4.5005
R62 VSS.n140 VSS.n139 4.5005
R63 VSS.n141 VSS.n104 4.5005
R64 VSS.n267 VSS.n0 4.5005
R65 VSS.n268 VSS.n267 4.5005
R66 VSS.n266 VSS.n3 4.5005
R67 VSS.n260 VSS.n4 4.5005
R68 VSS.n262 VSS.n261 4.5005
R69 VSS.n259 VSS.n7 4.5005
R70 VSS.n258 VSS.n257 4.5005
R71 VSS.n11 VSS.n10 4.5005
R72 VSS.n253 VSS.n252 4.5005
R73 VSS.n251 VSS.n15 4.5005
R74 VSS.n250 VSS.n249 4.5005
R75 VSS.n19 VSS.n18 4.5005
R76 VSS.n245 VSS.n244 4.5005
R77 VSS.n243 VSS.n24 4.5005
R78 VSS.n242 VSS.n241 4.5005
R79 VSS.n28 VSS.n27 4.5005
R80 VSS.n237 VSS.n236 4.5005
R81 VSS.n235 VSS.n32 4.5005
R82 VSS.n234 VSS.n233 4.5005
R83 VSS.n36 VSS.n35 4.5005
R84 VSS.n229 VSS.n228 4.5005
R85 VSS.n227 VSS.n40 4.5005
R86 VSS.n226 VSS.n225 4.5005
R87 VSS.n43 VSS.n42 4.5005
R88 VSS.n221 VSS.n220 4.5005
R89 VSS.n219 VSS.n47 4.5005
R90 VSS.n218 VSS.n217 4.5005
R91 VSS.n51 VSS.n50 4.5005
R92 VSS.n213 VSS.n212 4.5005
R93 VSS.n211 VSS.n55 4.5005
R94 VSS.n210 VSS.n209 4.5005
R95 VSS.n59 VSS.n58 4.5005
R96 VSS.n205 VSS.n204 4.5005
R97 VSS.n203 VSS.n63 4.5005
R98 VSS.n202 VSS.n201 4.5005
R99 VSS.n67 VSS.n66 4.5005
R100 VSS.n197 VSS.n196 4.5005
R101 VSS.n195 VSS.n71 4.5005
R102 VSS.n194 VSS.n193 4.5005
R103 VSS.n75 VSS.n74 4.5005
R104 VSS.n189 VSS.n188 4.5005
R105 VSS.n187 VSS.n79 4.5005
R106 VSS.n186 VSS.n185 4.5005
R107 VSS.n83 VSS.n82 4.5005
R108 VSS.n181 VSS.n180 4.5005
R109 VSS.n179 VSS.n87 4.5005
R110 VSS.n178 VSS.n177 4.5005
R111 VSS.n91 VSS.n90 4.5005
R112 VSS.n173 VSS.n96 4.5005
R113 VSS.n173 VSS.n172 4.5005
R114 VSS.n170 VSS.n91 4.5005
R115 VSS.n177 VSS.n93 4.5005
R116 VSS.n92 VSS.n87 4.5005
R117 VSS.n181 VSS.n89 4.5005
R118 VSS.n88 VSS.n83 4.5005
R119 VSS.n185 VSS.n85 4.5005
R120 VSS.n84 VSS.n79 4.5005
R121 VSS.n189 VSS.n81 4.5005
R122 VSS.n80 VSS.n75 4.5005
R123 VSS.n193 VSS.n77 4.5005
R124 VSS.n76 VSS.n71 4.5005
R125 VSS.n197 VSS.n73 4.5005
R126 VSS.n72 VSS.n67 4.5005
R127 VSS.n201 VSS.n69 4.5005
R128 VSS.n68 VSS.n63 4.5005
R129 VSS.n205 VSS.n65 4.5005
R130 VSS.n64 VSS.n59 4.5005
R131 VSS.n209 VSS.n61 4.5005
R132 VSS.n60 VSS.n55 4.5005
R133 VSS.n213 VSS.n57 4.5005
R134 VSS.n56 VSS.n51 4.5005
R135 VSS.n217 VSS.n53 4.5005
R136 VSS.n52 VSS.n47 4.5005
R137 VSS.n221 VSS.n49 4.5005
R138 VSS.n48 VSS.n43 4.5005
R139 VSS.n225 VSS.n45 4.5005
R140 VSS.n44 VSS.n40 4.5005
R141 VSS.n229 VSS.n41 4.5005
R142 VSS.n167 VSS.n36 4.5005
R143 VSS.n233 VSS.n38 4.5005
R144 VSS.n37 VSS.n32 4.5005
R145 VSS.n237 VSS.n34 4.5005
R146 VSS.n33 VSS.n28 4.5005
R147 VSS.n241 VSS.n30 4.5005
R148 VSS.n29 VSS.n24 4.5005
R149 VSS.n245 VSS.n26 4.5005
R150 VSS.n25 VSS.n19 4.5005
R151 VSS.n249 VSS.n22 4.5005
R152 VSS.n21 VSS.n15 4.5005
R153 VSS.n253 VSS.n17 4.5005
R154 VSS.n16 VSS.n11 4.5005
R155 VSS.n257 VSS.n13 4.5005
R156 VSS.n12 VSS.n7 4.5005
R157 VSS.n262 VSS.n9 4.5005
R158 VSS.n8 VSS.n4 4.5005
R159 VSS.n266 VSS.n5 4.5005
R160 VSS.n267 VSS.n2 4.5005
R161 VSS.n266 VSS.n265 4.5005
R162 VSS.n264 VSS.n4 4.5005
R163 VSS.n263 VSS.n262 4.5005
R164 VSS.n7 VSS.n6 4.5005
R165 VSS.n257 VSS.n256 4.5005
R166 VSS.n255 VSS.n11 4.5005
R167 VSS.n254 VSS.n253 4.5005
R168 VSS.n15 VSS.n14 4.5005
R169 VSS.n249 VSS.n248 4.5005
R170 VSS.n247 VSS.n19 4.5005
R171 VSS.n246 VSS.n245 4.5005
R172 VSS.n24 VSS.n23 4.5005
R173 VSS.n241 VSS.n240 4.5005
R174 VSS.n239 VSS.n28 4.5005
R175 VSS.n238 VSS.n237 4.5005
R176 VSS.n32 VSS.n31 4.5005
R177 VSS.n233 VSS.n232 4.5005
R178 VSS.n231 VSS.n36 4.5005
R179 VSS.n230 VSS.n229 4.5005
R180 VSS.n40 VSS.n39 4.5005
R181 VSS.n225 VSS.n224 4.5005
R182 VSS.n223 VSS.n43 4.5005
R183 VSS.n222 VSS.n221 4.5005
R184 VSS.n47 VSS.n46 4.5005
R185 VSS.n217 VSS.n216 4.5005
R186 VSS.n215 VSS.n51 4.5005
R187 VSS.n214 VSS.n213 4.5005
R188 VSS.n55 VSS.n54 4.5005
R189 VSS.n209 VSS.n208 4.5005
R190 VSS.n207 VSS.n59 4.5005
R191 VSS.n206 VSS.n205 4.5005
R192 VSS.n63 VSS.n62 4.5005
R193 VSS.n201 VSS.n200 4.5005
R194 VSS.n199 VSS.n67 4.5005
R195 VSS.n198 VSS.n197 4.5005
R196 VSS.n71 VSS.n70 4.5005
R197 VSS.n193 VSS.n192 4.5005
R198 VSS.n191 VSS.n75 4.5005
R199 VSS.n190 VSS.n189 4.5005
R200 VSS.n79 VSS.n78 4.5005
R201 VSS.n185 VSS.n184 4.5005
R202 VSS.n183 VSS.n83 4.5005
R203 VSS.n182 VSS.n181 4.5005
R204 VSS.n87 VSS.n86 4.5005
R205 VSS.n177 VSS.n176 4.5005
R206 VSS.n175 VSS.n91 4.5005
R207 VSS.n174 VSS.n173 4.5005
R208 VSS.n95 VSS.n94 4.5005
R209 VSS.n124 VSS.n123 4.5005
R210 VSS.n125 VSS.n119 4.5005
R211 VSS.n127 VSS.n126 4.5005
R212 VSS.n128 VSS.n114 4.5005
R213 VSS.n130 VSS.n129 4.5005
R214 VSS.n131 VSS.n113 4.5005
R215 VSS.n133 VSS.n132 4.5005
R216 VSS.n134 VSS.n109 4.5005
R217 VSS.n136 VSS.n135 4.5005
R218 VSS.n137 VSS.n106 4.5005
R219 VSS.n139 VSS.n138 4.5005
R220 VSS.n108 VSS.n104 4.5005
R221 VSS.n107 VSS.t7 3.69605
R222 VSS.n171 VSS.t2 3.10066
R223 VSS.n107 VSS.t6 1.362
R224 VSS.n172 VSS.t1 1.3425
R225 VSS.t9 VSS.n162 1.3125
R226 VSS.n271 VSS.n1 1.07202
R227 VSS.n269 VSS.n1 0.846223
R228 VSS.n269 VSS.n268 0.24875
R229 VSS.t11 VSS.n168 0.24236
R230 VSS.n271 VSS.n270 0.220715
R231 VSS VSS.n271 0.202016
R232 VSS.n270 VSS.n269 0.107359
R233 VSS.n160 VSS.n159 0.0905
R234 VSS.n159 VSS.n158 0.0905
R235 VSS.n158 VSS.n99 0.0905
R236 VSS.n154 VSS.n99 0.0905
R237 VSS.n154 VSS.n153 0.0905
R238 VSS.n153 VSS.n152 0.0905
R239 VSS.n152 VSS.n101 0.0905
R240 VSS.n148 VSS.n101 0.0905
R241 VSS.n148 VSS.n147 0.0905
R242 VSS.n147 VSS.n146 0.0905
R243 VSS.n146 VSS.n103 0.0905
R244 VSS.n142 VSS.n103 0.0905
R245 VSS.n142 VSS.n141 0.0905
R246 VSS.n141 VSS.n140 0.0905
R247 VSS.n140 VSS.n105 0.0905
R248 VSS.n110 VSS.n105 0.0905
R249 VSS.n111 VSS.n110 0.0905
R250 VSS.n112 VSS.n111 0.0905
R251 VSS.n115 VSS.n112 0.0905
R252 VSS.n116 VSS.n115 0.0905
R253 VSS.n117 VSS.n116 0.0905
R254 VSS.n118 VSS.n117 0.0905
R255 VSS.n120 VSS.n118 0.0905
R256 VSS.n122 VSS.n120 0.0905
R257 VSS.n122 VSS.n121 0.0905
R258 VSS.n121 VSS.n96 0.0905
R259 VSS.n96 VSS.n90 0.0905
R260 VSS.n178 VSS.n90 0.0905
R261 VSS.n179 VSS.n178 0.0905
R262 VSS.n180 VSS.n179 0.0905
R263 VSS.n180 VSS.n82 0.0905
R264 VSS.n186 VSS.n82 0.0905
R265 VSS.n187 VSS.n186 0.0905
R266 VSS.n188 VSS.n187 0.0905
R267 VSS.n188 VSS.n74 0.0905
R268 VSS.n194 VSS.n74 0.0905
R269 VSS.n195 VSS.n194 0.0905
R270 VSS.n196 VSS.n195 0.0905
R271 VSS.n196 VSS.n66 0.0905
R272 VSS.n202 VSS.n66 0.0905
R273 VSS.n203 VSS.n202 0.0905
R274 VSS.n204 VSS.n203 0.0905
R275 VSS.n204 VSS.n58 0.0905
R276 VSS.n210 VSS.n58 0.0905
R277 VSS.n211 VSS.n210 0.0905
R278 VSS.n212 VSS.n211 0.0905
R279 VSS.n212 VSS.n50 0.0905
R280 VSS.n218 VSS.n50 0.0905
R281 VSS.n219 VSS.n218 0.0905
R282 VSS.n220 VSS.n219 0.0905
R283 VSS.n220 VSS.n42 0.0905
R284 VSS.n226 VSS.n42 0.0905
R285 VSS.n227 VSS.n226 0.0905
R286 VSS.n228 VSS.n227 0.0905
R287 VSS.n228 VSS.n35 0.0905
R288 VSS.n234 VSS.n35 0.0905
R289 VSS.n235 VSS.n234 0.0905
R290 VSS.n236 VSS.n235 0.0905
R291 VSS.n236 VSS.n27 0.0905
R292 VSS.n242 VSS.n27 0.0905
R293 VSS.n243 VSS.n242 0.0905
R294 VSS.n244 VSS.n243 0.0905
R295 VSS.n244 VSS.n18 0.0905
R296 VSS.n250 VSS.n18 0.0905
R297 VSS.n251 VSS.n250 0.0905
R298 VSS.n252 VSS.n251 0.0905
R299 VSS.n252 VSS.n10 0.0905
R300 VSS.n258 VSS.n10 0.0905
R301 VSS.n259 VSS.n258 0.0905
R302 VSS.n261 VSS.n259 0.0905
R303 VSS.n261 VSS.n260 0.0905
R304 VSS.n260 VSS.n3 0.0905
R305 VSS.n268 VSS.n3 0.0905
R306 VSS.n170 VSS.n93 0.0905
R307 VSS.n93 VSS.n92 0.0905
R308 VSS.n92 VSS.n89 0.0905
R309 VSS.n89 VSS.n88 0.0905
R310 VSS.n88 VSS.n85 0.0905
R311 VSS.n85 VSS.n84 0.0905
R312 VSS.n84 VSS.n81 0.0905
R313 VSS.n81 VSS.n80 0.0905
R314 VSS.n80 VSS.n77 0.0905
R315 VSS.n77 VSS.n76 0.0905
R316 VSS.n76 VSS.n73 0.0905
R317 VSS.n138 VSS.n108 0.0905
R318 VSS.n138 VSS.n137 0.0905
R319 VSS.n137 VSS.n136 0.0905
R320 VSS.n136 VSS.n109 0.0905
R321 VSS.n132 VSS.n109 0.0905
R322 VSS.n132 VSS.n131 0.0905
R323 VSS.n131 VSS.n130 0.0905
R324 VSS.n130 VSS.n114 0.0905
R325 VSS.n126 VSS.n114 0.0905
R326 VSS.n126 VSS.n125 0.0905
R327 VSS.n125 VSS.n124 0.0905
R328 VSS.n124 VSS.n94 0.0905
R329 VSS.n174 VSS.n94 0.0905
R330 VSS.n175 VSS.n174 0.0905
R331 VSS.n176 VSS.n175 0.0905
R332 VSS.n176 VSS.n86 0.0905
R333 VSS.n182 VSS.n86 0.0905
R334 VSS.n183 VSS.n182 0.0905
R335 VSS.n184 VSS.n183 0.0905
R336 VSS.n184 VSS.n78 0.0905
R337 VSS.n190 VSS.n78 0.0905
R338 VSS.n191 VSS.n190 0.0905
R339 VSS.n192 VSS.n191 0.0905
R340 VSS.n192 VSS.n70 0.0905
R341 VSS.n198 VSS.n70 0.0905
R342 VSS.n199 VSS.n198 0.0905
R343 VSS.n200 VSS.n199 0.0905
R344 VSS.n200 VSS.n62 0.0905
R345 VSS.n206 VSS.n62 0.0905
R346 VSS.n207 VSS.n206 0.0905
R347 VSS.n208 VSS.n207 0.0905
R348 VSS.n208 VSS.n54 0.0905
R349 VSS.n214 VSS.n54 0.0905
R350 VSS.n215 VSS.n214 0.0905
R351 VSS.n216 VSS.n215 0.0905
R352 VSS.n216 VSS.n46 0.0905
R353 VSS.n222 VSS.n46 0.0905
R354 VSS.n223 VSS.n222 0.0905
R355 VSS.n224 VSS.n223 0.0905
R356 VSS.n224 VSS.n39 0.0905
R357 VSS.n230 VSS.n39 0.0905
R358 VSS.n231 VSS.n230 0.0905
R359 VSS.n232 VSS.n231 0.0905
R360 VSS.n232 VSS.n31 0.0905
R361 VSS.n238 VSS.n31 0.0905
R362 VSS.n239 VSS.n238 0.0905
R363 VSS.n240 VSS.n239 0.0905
R364 VSS.n240 VSS.n23 0.0905
R365 VSS.n246 VSS.n23 0.0905
R366 VSS.n247 VSS.n246 0.0905
R367 VSS.n248 VSS.n247 0.0905
R368 VSS.n248 VSS.n14 0.0905
R369 VSS.n254 VSS.n14 0.0905
R370 VSS.n255 VSS.n254 0.0905
R371 VSS.n256 VSS.n255 0.0905
R372 VSS.n256 VSS.n6 0.0905
R373 VSS.n263 VSS.n6 0.0905
R374 VSS.n264 VSS.n263 0.0905
R375 VSS.n265 VSS.n264 0.0905
R376 VSS.n265 VSS.n2 0.0905
R377 VSS.n73 VSS.n72 0.0813125
R378 VSS.n5 VSS.n0 0.0798125
R379 VSS.n272 VSS.n0 0.0785
R380 VSS.n270 VSS.n2 0.0785
R381 VSS.n171 VSS.n170 0.071
R382 VSS.n72 VSS.n69 0.068
R383 VSS.n69 VSS.n68 0.068
R384 VSS.n68 VSS.n65 0.068
R385 VSS.n65 VSS.n64 0.068
R386 VSS.n64 VSS.n61 0.068
R387 VSS.n61 VSS.n60 0.068
R388 VSS.n60 VSS.n57 0.068
R389 VSS.n57 VSS.n56 0.068
R390 VSS.n56 VSS.n53 0.068
R391 VSS.n53 VSS.n52 0.068
R392 VSS.n52 VSS.n49 0.068
R393 VSS.n49 VSS.n48 0.068
R394 VSS.n48 VSS.n45 0.068
R395 VSS.n45 VSS.n44 0.068
R396 VSS.n44 VSS.n41 0.068
R397 VSS.n167 VSS.n41 0.068
R398 VSS.n38 VSS.n37 0.068
R399 VSS.n37 VSS.n34 0.068
R400 VSS.n34 VSS.n33 0.068
R401 VSS.n33 VSS.n30 0.068
R402 VSS.n30 VSS.n29 0.068
R403 VSS.n29 VSS.n26 0.068
R404 VSS.n26 VSS.n25 0.068
R405 VSS.n25 VSS.n22 0.068
R406 VSS.n22 VSS.n21 0.068
R407 VSS.n17 VSS.n16 0.068
R408 VSS.n16 VSS.n13 0.068
R409 VSS.n13 VSS.n12 0.068
R410 VSS.n12 VSS.n9 0.068
R411 VSS.n9 VSS.n8 0.068
R412 VSS.n8 VSS.n5 0.068
R413 VSS.n162 VSS.n97 0.05
R414 VSS VSS.n272 0.0455
R415 VSS.n160 VSS.n97 0.041
R416 VSS.n168 VSS.n167 0.0365
R417 VSS.n21 VSS.n20 0.0365
R418 VSS.n168 VSS.n38 0.032
R419 VSS.n20 VSS.n17 0.032
R420 VSS.n161 VSS.n98 0.0233814
R421 VSS.n157 VSS.n98 0.0233814
R422 VSS.n157 VSS.n156 0.0233814
R423 VSS.n156 VSS.n155 0.0233814
R424 VSS.n155 VSS.n100 0.0233814
R425 VSS.n151 VSS.n100 0.0233814
R426 VSS.n151 VSS.n150 0.0233814
R427 VSS.n150 VSS.n149 0.0233814
R428 VSS.n149 VSS.n102 0.0233814
R429 VSS.n145 VSS.n102 0.0233814
R430 VSS.n145 VSS.n144 0.0233814
R431 VSS.n144 VSS.n143 0.0233814
R432 VSS.n172 VSS.n171 0.02
R433 VSS.n143 VSS.n104 0.0142288
R434 VSS.n139 VSS.n104 0.0119407
R435 VSS.n139 VSS.n106 0.0119407
R436 VSS.n135 VSS.n106 0.0119407
R437 VSS.n135 VSS.n134 0.0119407
R438 VSS.n134 VSS.n133 0.0119407
R439 VSS.n133 VSS.n113 0.0119407
R440 VSS.n129 VSS.n113 0.0119407
R441 VSS.n129 VSS.n128 0.0119407
R442 VSS.n128 VSS.n127 0.0119407
R443 VSS.n127 VSS.n119 0.0119407
R444 VSS.n123 VSS.n119 0.0119407
R445 VSS.n123 VSS.n95 0.0119407
R446 VSS.n108 VSS.n107 0.011
R447 VSS.n173 VSS.n95 0.010161
R448 VSS.n173 VSS.n91 0.00812712
R449 VSS.n177 VSS.n91 0.00812712
R450 VSS.n177 VSS.n87 0.00812712
R451 VSS.n181 VSS.n87 0.00812712
R452 VSS.n181 VSS.n83 0.00812712
R453 VSS.n185 VSS.n83 0.00812712
R454 VSS.n185 VSS.n79 0.00812712
R455 VSS.n189 VSS.n79 0.00812712
R456 VSS.n189 VSS.n75 0.00812712
R457 VSS.n193 VSS.n75 0.00812712
R458 VSS.n193 VSS.n71 0.00812712
R459 VSS.n197 VSS.n71 0.00812712
R460 VSS.n197 VSS.n67 0.00812712
R461 VSS.n201 VSS.n67 0.00812712
R462 VSS.n201 VSS.n63 0.00812712
R463 VSS.n205 VSS.n63 0.00812712
R464 VSS.n205 VSS.n59 0.00812712
R465 VSS.n209 VSS.n59 0.00812712
R466 VSS.n209 VSS.n55 0.00812712
R467 VSS.n213 VSS.n55 0.00812712
R468 VSS.n213 VSS.n51 0.00812712
R469 VSS.n217 VSS.n51 0.00812712
R470 VSS.n217 VSS.n47 0.00812712
R471 VSS.n221 VSS.n47 0.00812712
R472 VSS.n221 VSS.n43 0.00812712
R473 VSS.n225 VSS.n43 0.00812712
R474 VSS.n225 VSS.n40 0.00812712
R475 VSS.n229 VSS.n40 0.00812712
R476 VSS.n229 VSS.n36 0.00812712
R477 VSS.n233 VSS.n36 0.00812712
R478 VSS.n233 VSS.n32 0.00812712
R479 VSS.n237 VSS.n32 0.00812712
R480 VSS.n237 VSS.n28 0.00812712
R481 VSS.n241 VSS.n28 0.00812712
R482 VSS.n241 VSS.n24 0.00812712
R483 VSS.n245 VSS.n24 0.00812712
R484 VSS.n245 VSS.n19 0.00812712
R485 VSS.n249 VSS.n19 0.00812712
R486 VSS.n249 VSS.n15 0.00812712
R487 VSS.n253 VSS.n15 0.00812712
R488 VSS.n253 VSS.n11 0.00812712
R489 VSS.n257 VSS.n11 0.00812712
R490 VSS.n257 VSS.n7 0.00812712
R491 VSS.n262 VSS.n7 0.00812712
R492 VSS.n262 VSS.n4 0.00812712
R493 VSS.n266 VSS.n4 0.00812712
R494 VSS.n267 VSS.n266 0.00812712
R495 VSS.n272 VSS 0.008
R496 VSS.n267 VSS.n1 0.00711017
R497 a_100_n800.t0 a_100_n800.n0 13.815
R498 a_100_n800.n0 a_100_n800.t1 17.1417
R499 a_100_n800.n0 a_100_n800.t2 11.8864
R500 a_2430_n800.t0 a_2430_n800.n0 19.9355
R501 a_2430_n800.n0 a_2430_n800.t2 0.626128
R502 a_2430_n800.n0 a_2430_n800.t1 21.5172
R503 a_938_3424.t1 a_938_3424.n0 15.458
R504 a_938_3424.n0 a_938_3424.n1 0.693179
R505 a_938_3424.n1 a_938_3424.t3 159.727
R506 a_938_3424.n1 a_938_3424.t0 157.845
R507 a_938_3424.n0 a_938_3424.t2 19.6007
R508 a_8030_n1600.t1 a_8030_n1600.n0 23.415
R509 a_8030_n1600.n0 a_8030_n1600.t2 21.4021
R510 a_8030_n1600.n0 a_8030_n1600.t0 28.2014
R511 a_2156_7176.t2 a_2156_7176.n0 22.7079
R512 a_2156_7176.n0 a_2156_7176.t1 15.5022
R513 a_2156_7176.n0 a_2156_7176.t0 15.4145
R514 a_2156_7176.n0 a_2156_7176.n1 15.6493
R515 a_2156_7176.n1 a_2156_7176.t3 202.025
R516 a_2156_7176.n1 a_2156_7176.t4 378.755
R517 a_1676_7176.t0 a_1676_7176.t1 18.4426
R518 a_1676_7176.t1 a_1676_7176.n0 11.5398
R519 a_1676_7176.n0 a_1676_7176.t2 119.855
R520 a_1676_7176.n0 a_1676_7176.t3 175.95
R521 a_6430_n1100.t1 a_6430_n1100.n0 18.669
R522 a_6430_n1100.n0 a_6430_n1100.t0 20.8513
R523 a_6430_n1100.n0 a_6430_n1100.n1 15.6493
R524 a_6430_n1100.n1 a_6430_n1100.t2 265.752
R525 a_6430_n1100.n1 a_6430_n1100.t3 600.648
C7 INM VSS 0.73625f
C8 INP VSS 0.72362f
C9 IBIAS VSS 1.12052f
C10 OUT VSS 0.52991f
C11 VDD VSS 0.11595p
C12 m1_3129_7189# VSS 0.17907f
C13 a_6430_n1100.t1 VSS 1.20933f $ **FLOATING
C14 a_6430_n1100.n0 VSS 1.6799f $ **FLOATING
C15 a_6430_n1100.t3 VSS 1.42069f $ **FLOATING
C16 a_6430_n1100.t2 VSS 0.55371f $ **FLOATING
C17 a_6430_n1100.n1 VSS 3.23427f $ **FLOATING
C18 a_6430_n1100.t0 VSS 2.47039f $ **FLOATING
C19 a_1676_7176.t0 VSS 0.10143f $ **FLOATING
C20 a_1676_7176.t1 VSS 2.60005f $ **FLOATING
C21 a_1676_7176.t3 VSS 0.20899f $ **FLOATING
C22 a_1676_7176.t2 VSS 0.11833f $ **FLOATING
C23 a_1676_7176.n0 VSS 0.84158f $ **FLOATING
C24 a_2156_7176.t2 VSS 0.372f $ **FLOATING
C25 a_2156_7176.n0 VSS 1.82933f $ **FLOATING
C26 a_2156_7176.t4 VSS 0.73935f $ **FLOATING
C27 a_2156_7176.t3 VSS 0.33564f $ **FLOATING
C28 a_2156_7176.n1 VSS 1.98328f $ **FLOATING
C29 a_2156_7176.t0 VSS 0.83514f $ **FLOATING
C30 a_2156_7176.t1 VSS 0.42149f $ **FLOATING
C31 a_8030_n1600.t1 VSS 0.25228f $ **FLOATING
C32 a_8030_n1600.t0 VSS 4.68093f $ **FLOATING
C33 a_8030_n1600.t2 VSS 1.93043f $ **FLOATING
C34 a_8030_n1600.n0 VSS 2.5583f $ **FLOATING
C35 a_938_3424.t1 VSS 0.88495f $ **FLOATING
C36 a_938_3424.t2 VSS 1.01975f $ **FLOATING
C37 a_938_3424.n0 VSS 0.68752f $ **FLOATING
C38 a_938_3424.n1 VSS 0.80167f $ **FLOATING
C39 a_938_3424.t0 VSS 0.34707f $ **FLOATING
C40 a_938_3424.t3 VSS 0.35152f $ **FLOATING
C41 a_2430_n800.t0 VSS 0.19954f $ **FLOATING
C42 a_2430_n800.t1 VSS 0.22115f $ **FLOATING
C43 a_2430_n800.t2 VSS 3.06686f $ **FLOATING
C44 a_2430_n800.n0 VSS 0.47708f $ **FLOATING
C45 a_100_n800.t0 VSS 0.44606f $ **FLOATING
C46 a_100_n800.t2 VSS 0.42751f $ **FLOATING
C47 a_100_n800.n0 VSS 0.58207f $ **FLOATING
C48 a_100_n800.t1 VSS 0.49891f $ **FLOATING
C49 VDD.t5 VSS 0.86955f $ **FLOATING
C50 VDD.t4 VSS 5.38861f $ **FLOATING
C51 VDD.n0 VSS 2.51749f $ **FLOATING
C52 VDD.t3 VSS 0.52864f $ **FLOATING
C53 VDD.t2 VSS 3.35276f $ **FLOATING
C54 VDD.n1 VSS 1.56678f $ **FLOATING
C55 VDD.n2 VSS 1.22793f $ **FLOATING
C56 VDD.t9 VSS 0.22006f $ **FLOATING
C57 VDD.t8 VSS 1.54313f $ **FLOATING
C58 VDD.n3 VSS 0.84259f $ **FLOATING
C59 VDD.n4 VSS 0.57789f $ **FLOATING
C60 VDD.t6 VSS 2.41287f $ **FLOATING
C61 VDD.t0 VSS 4.22404f $ **FLOATING
C62 VDD.t7 VSS 0.13386f $ **FLOATING
C63 VDD.t1 VSS 0.12523f $ **FLOATING
C64 VDD.n5 VSS 0.12002f $ **FLOATING
C65 VDD.n6 VSS 0.24406f $ **FLOATING
C66 OUT.t0 VSS 0.02581f $ **FLOATING
C67 IBIAS.t0 VSS 0.30151f $ **FLOATING
C68 INP.t0 VSS 0.15981f $ **FLOATING
C69 INM.t0 VSS 0.15036f $ **FLOATING
