* ib_conv_v1_pex -- flat R+C PEX wrapped as a subckt.
* External terminals are the bare port-label nodes (rule: exact port-label name):
*   IBIAS INP INM OUT VDD VSS. All VDD.tN / VSS.tN / VSS.nNNN stay INTERNAL and are
*   NOT tied together -- tying them would short out the extracted bus resistance.
* Generated with ext2spice scale off, so dimensions are absolute and mix with the
*   absolute-unit DIV2 bench. The committed .pex.spice carries .option scale=5n and
*   is NOT mixable.
.subckt ib_conv_v1_pex_norvss IBIAS INP INM OUT VDD VSS
X0 a_938_3424.t2 INP.t0 a_100_n800.t2 VSS nfet_03v3 ad=3.52p pd=16.88u as=3.52p ps=16.88u w=8u l=0.3u
X1 a_938_3424.t1 a_938_3424.t0 VDD.t1 VDD.t0 pfet_03v3 ad=3.52p pd=16.88u as=3.52p ps=16.88u w=8u l=0.3u
X2 a_8030_n1600.t0 a_6430_n1100.t3 VDD.t5 VDD.t4 pfet_03v3 ad=19.36p pd=88.88u as=19.36p ps=88.88u w=44u l=0.3u
X3 a_8030_n1600.t2 a_6430_n1100.t2 VSS VSS nfet_03v3 ad=7.04p pd=32.88u as=7.04p ps=32.88u w=16u l=0.3u
X4 a_6430_n1100.t0 a_2156_7176.t4 VDD.t3 VDD.t2 pfet_03v3 ad=11.44p pd=52.88u as=11.44p ps=52.88u w=26u l=0.3u
X5 a_2430_n800.t1 INM.t0 a_100_n800.t0 VSS nfet_03v3 ad=3.52p pd=16.88u as=3.52p ps=16.88u w=8u l=0.3u
X6 a_6430_n1100.t1 a_2156_7176.t3 VSS VSS nfet_03v3 ad=4.84p pd=22.88u as=4.84p ps=22.88u w=11u l=0.3u
X7 OUT.t0 a_8030_n1600.t1 VSS ppolyf_u_1k r_width=2u r_length=2u
X8 a_2156_7176.t1 a_1676_7176.t2 VSS VSS nfet_03v3 ad=1.76p pd=8.88u as=1.76p ps=8.88u w=4u l=0.3u
X9 a_100_n800.t1 IBIAS.t0 VSS VSS nfet_03v3 ad=3.52p pd=16.88u as=3.52p ps=16.88u w=8u l=1u
X10 a_2156_7176.t0 a_1676_7176.t3 VDD.t9 VDD.t8 pfet_03v3 ad=4.4p pd=20.88u as=4.4p ps=20.88u w=10u l=0.3u
X11 a_2430_n800.t0 a_938_3424.t3 VDD.t7 VDD.t6 pfet_03v3 ad=3.52p pd=16.88u as=3.52p ps=16.88u w=8u l=0.3u
X12 a_2430_n800.t2 a_1676_7176.t1 cap_mim_2f0_m4m5_noshield c_width=5u c_length=10u
X13 a_2156_7176.t2 a_1676_7176.t0 VSS ppolyf_u_1k r_width=2u r_length=40.04u
C0 INM INP 0.0187f
C1 INP VDD 0.03938f
C2 m1_3129_7189# VDD 0.00196f
C3 OUT VDD 0.0071f
C4 INM VDD 0.03938f
C5 IBIAS INP 0.01831f
C6 IBIAS VDD 0.05655f
R0 INM INM.t0 163.077
R1 INP INP.t0 163.077
R2 IBIAS IBIAS.t0 79.7738
R3 OUT OUT.t0 3.62478
R4 VDD.n0 VDD.t4 4010.79
R5 VDD.n1 VDD.t2 2510.79
R6 VDD.n3 VDD.t8 1177.45
R7 VDD.t0 VDD.t6 468.75
R8 VDD.n0 VDD.t5 41.935
R9 VDD.n1 VDD.t3 32.6948
R10 VDD.n3 VDD.t9 24.6866
R11 VDD.n6 VDD.n5 17.1101
R12 VDD.n2 VDD.n0 14.4605
R13 VDD.n2 VDD.n1 10.2755
R14 VDD.n4 VDD.n3 9.0755
R15 VDD.n5 VDD.t7 8.25479
R16 VDD.n5 VDD.t1 6.32622
R17 VDD VDD.n6 5.89737
R18 VDD.n4 VDD.n2 2.8355
R19 VDD VDD.n4 1.6835
R20 VDD.n6 VDD.t0 0.546648
R497 a_100_n800.t0 a_100_n800.n0 13.815
R498 a_100_n800.n0 a_100_n800.t1 17.1417
R499 a_100_n800.n0 a_100_n800.t2 11.8864
R500 a_2430_n800.t0 a_2430_n800.n0 19.9355
R501 a_2430_n800.n0 a_2430_n800.t2 0.626128
R502 a_2430_n800.n0 a_2430_n800.t1 21.5172
R503 a_938_3424.t1 a_938_3424.n0 15.458
R504 a_938_3424.n0 a_938_3424.n1 0.693179
R505 a_938_3424.n1 a_938_3424.t3 159.727
R506 a_938_3424.n1 a_938_3424.t0 157.845
R507 a_938_3424.n0 a_938_3424.t2 19.6007
R508 a_8030_n1600.t1 a_8030_n1600.n0 23.415
R509 a_8030_n1600.n0 a_8030_n1600.t2 21.4021
R510 a_8030_n1600.n0 a_8030_n1600.t0 28.2014
R511 a_2156_7176.t2 a_2156_7176.n0 22.7079
R512 a_2156_7176.n0 a_2156_7176.t1 15.5022
R513 a_2156_7176.n0 a_2156_7176.t0 15.4145
R514 a_2156_7176.n0 a_2156_7176.n1 15.6493
R515 a_2156_7176.n1 a_2156_7176.t3 202.025
R516 a_2156_7176.n1 a_2156_7176.t4 378.755
R517 a_1676_7176.t0 a_1676_7176.t1 18.4426
R518 a_1676_7176.t1 a_1676_7176.n0 11.5398
R519 a_1676_7176.n0 a_1676_7176.t2 119.855
R520 a_1676_7176.n0 a_1676_7176.t3 175.95
R521 a_6430_n1100.t1 a_6430_n1100.n0 18.669
R522 a_6430_n1100.n0 a_6430_n1100.t0 20.8513
R523 a_6430_n1100.n0 a_6430_n1100.n1 15.6493
R524 a_6430_n1100.n1 a_6430_n1100.t2 265.752
R525 a_6430_n1100.n1 a_6430_n1100.t3 600.648
C7 INM VSS 0.73625f
C8 INP VSS 0.72362f
C9 IBIAS VSS 1.12052f
C10 OUT VSS 0.52991f
C11 VDD VSS 0.11595p
C12 m1_3129_7189# VSS 0.17907f
C13 a_6430_n1100.t1 VSS 1.20933f $ **FLOATING
C14 a_6430_n1100.n0 VSS 1.6799f $ **FLOATING
C15 a_6430_n1100.t3 VSS 1.42069f $ **FLOATING
C16 a_6430_n1100.t2 VSS 0.55371f $ **FLOATING
C17 a_6430_n1100.n1 VSS 3.23427f $ **FLOATING
C18 a_6430_n1100.t0 VSS 2.47039f $ **FLOATING
C19 a_1676_7176.t0 VSS 0.10143f $ **FLOATING
C20 a_1676_7176.t1 VSS 2.60005f $ **FLOATING
C21 a_1676_7176.t3 VSS 0.20899f $ **FLOATING
C22 a_1676_7176.t2 VSS 0.11833f $ **FLOATING
C23 a_1676_7176.n0 VSS 0.84158f $ **FLOATING
C24 a_2156_7176.t2 VSS 0.372f $ **FLOATING
C25 a_2156_7176.n0 VSS 1.82933f $ **FLOATING
C26 a_2156_7176.t4 VSS 0.73935f $ **FLOATING
C27 a_2156_7176.t3 VSS 0.33564f $ **FLOATING
C28 a_2156_7176.n1 VSS 1.98328f $ **FLOATING
C29 a_2156_7176.t0 VSS 0.83514f $ **FLOATING
C30 a_2156_7176.t1 VSS 0.42149f $ **FLOATING
C31 a_8030_n1600.t1 VSS 0.25228f $ **FLOATING
C32 a_8030_n1600.t0 VSS 4.68093f $ **FLOATING
C33 a_8030_n1600.t2 VSS 1.93043f $ **FLOATING
C34 a_8030_n1600.n0 VSS 2.5583f $ **FLOATING
C35 a_938_3424.t1 VSS 0.88495f $ **FLOATING
C36 a_938_3424.t2 VSS 1.01975f $ **FLOATING
C37 a_938_3424.n0 VSS 0.68752f $ **FLOATING
C38 a_938_3424.n1 VSS 0.80167f $ **FLOATING
C39 a_938_3424.t0 VSS 0.34707f $ **FLOATING
C40 a_938_3424.t3 VSS 0.35152f $ **FLOATING
C41 a_2430_n800.t0 VSS 0.19954f $ **FLOATING
C42 a_2430_n800.t1 VSS 0.22115f $ **FLOATING
C43 a_2430_n800.t2 VSS 3.06686f $ **FLOATING
C44 a_2430_n800.n0 VSS 0.47708f $ **FLOATING
C45 a_100_n800.t0 VSS 0.44606f $ **FLOATING
C46 a_100_n800.t2 VSS 0.42751f $ **FLOATING
C47 a_100_n800.n0 VSS 0.58207f $ **FLOATING
C48 a_100_n800.t1 VSS 0.49891f $ **FLOATING
C49 VDD.t5 VSS 0.86955f $ **FLOATING
C50 VDD.t4 VSS 5.38861f $ **FLOATING
C51 VDD.n0 VSS 2.51749f $ **FLOATING
C52 VDD.t3 VSS 0.52864f $ **FLOATING
C53 VDD.t2 VSS 3.35276f $ **FLOATING
C54 VDD.n1 VSS 1.56678f $ **FLOATING
C55 VDD.n2 VSS 1.22793f $ **FLOATING
C56 VDD.t9 VSS 0.22006f $ **FLOATING
C57 VDD.t8 VSS 1.54313f $ **FLOATING
C58 VDD.n3 VSS 0.84259f $ **FLOATING
C59 VDD.n4 VSS 0.57789f $ **FLOATING
C60 VDD.t6 VSS 2.41287f $ **FLOATING
C61 VDD.t0 VSS 4.22404f $ **FLOATING
C62 VDD.t7 VSS 0.13386f $ **FLOATING
C63 VDD.t1 VSS 0.12523f $ **FLOATING
C64 VDD.n5 VSS 0.12002f $ **FLOATING
C65 VDD.n6 VSS 0.24406f $ **FLOATING
C66 OUT.t0 VSS 0.02581f $ **FLOATING
C67 IBIAS.t0 VSS 0.30151f $ **FLOATING
C68 INP.t0 VSS 0.15981f $ **FLOATING
C69 INM.t0 VSS 0.15036f $ **FLOATING
.ends ib_conv_v1_pex_norvss
