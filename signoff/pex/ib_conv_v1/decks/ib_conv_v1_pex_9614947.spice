* ib_conv_v1_pex -- flat R+C PEX wrapped as a subckt.
* External terminals are the bare port-label nodes (rule: exact port-label name):
*   IBIAS INP INM OUT VDD VSS. All VDD.tN / VSS.tN / VSS.nNNN stay INTERNAL and are
*   NOT tied together -- tying them would short out the extracted bus resistance.
* Generated with ext2spice scale off, so dimensions are absolute and mix with the
*   absolute-unit DIV2 bench. The committed .pex.spice carries .option scale=5n and
*   is NOT mixable.
.subckt ib_conv_v1_pex IBIAS INP INM OUT VDD VSS

X0 a_938_3424.t0 INP.t0 a_100_n800.t0 VSS.t0 nfet_03v3 ad=3.52p pd=16.88u as=3.52p ps=16.88u w=8u l=0.3u
X1 a_938_3424.t2 a_938_3424.t1 VDD.t3 VDD.t2 pfet_03v3 ad=3.52p pd=16.88u as=3.52p ps=16.88u w=8u l=0.3u
X2 a_8030_n1600.t2 a_6430_n1100.t3 VDD.t5 VDD.t4 pfet_03v3 ad=19.36p pd=88.88u as=19.36p ps=88.88u w=44u l=0.3u
X3 a_8030_n1600.t1 a_6430_n1100.t2 VSS.t7 VSS.t6 nfet_03v3 ad=7.04p pd=32.88u as=7.04p ps=32.88u w=16u l=0.3u
X4 a_6430_n1100.t0 a_2156_7176.t4 VDD.t9 VDD.t8 pfet_03v3 ad=11.44p pd=52.88u as=11.44p ps=52.88u w=26u l=0.3u
X5 a_2430_n800.t1 INM.t0 a_100_n800.t2 VSS.t5 nfet_03v3 ad=3.52p pd=16.88u as=3.52p ps=16.88u w=8u l=0.3u
X6 a_6430_n1100.t1 a_2156_7176.t3 VSS.t11 VSS.t10 nfet_03v3 ad=4.84p pd=22.88u as=4.84p ps=22.88u w=11u l=0.3u
X7 OUT.t0 a_8030_n1600.t0 VSS.t3 ppolyf_u_1k r_width=2u r_length=2u
X8 a_2156_7176.t1 a_1676_7176.t2 VSS.t9 VSS.t8 nfet_03v3 ad=1.76p pd=8.88u as=1.76p ps=8.88u w=4u l=0.3u
X9 a_100_n800.t1 IBIAS.t0 VSS.t2 VSS.t1 nfet_03v3 ad=3.52p pd=16.88u as=3.52p ps=16.88u w=8u l=1u
X10 a_2156_7176.t2 a_1676_7176.t3 VDD.t7 VDD.t6 pfet_03v3 ad=4.4p pd=20.88u as=4.4p ps=20.88u w=10u l=0.3u
X11 a_2430_n800.t0 a_938_3424.t3 VDD.t1 VDD.t0 pfet_03v3 ad=3.52p pd=16.88u as=3.52p ps=16.88u w=8u l=0.3u
X12 a_2430_n800.t2 a_1676_7176.t1 cap_mim_2f0_m4m5_noshield c_width=5u c_length=10u
X13 a_2156_7176.t0 a_1676_7176.t0 VSS.t4 ppolyf_u_1k r_width=2u r_length=40.04u
C0 OUT VDD 0.0071f
C1 INP IBIAS 0.01831f
C2 IBIAS VDD 0.05655f
C3 VDD m1_3129_7189# 0.00196f
C4 INP INM 0.0187f
C5 INM VDD 0.03938f
C6 INP VDD 0.03938f
R0 INM INM.t0 163.077
R1 INP INP.t0 163.077
R2 IBIAS IBIAS.t0 79.7738
R3 OUT OUT.t0 3.62478
R4 VDD.n18 VDD.t4 4010.79
R5 VDD.n19 VDD.t8 2510.79
R6 VDD.n0 VDD.t6 1177.45
R7 VDD.t2 VDD.t0 468.75
R8 VDD.n18 VDD.t5 41.935
R9 VDD.n19 VDD.t9 32.6948
R10 VDD.n0 VDD.t7 24.6866
R11 VDD.n72 VDD.n71 17.1101
R12 VDD.n21 VDD.n18 9.56022
R13 VDD.n71 VDD.t1 8.25479
R14 VDD.n20 VDD.n19 7.2365
R15 VDD.n71 VDD.t3 6.32622
R16 VDD.n1 VDD.n0 6.0365
R17 VDD VDD.n72 5.89737
R18 VDD.n22 VDD.n17 4.5005
R19 VDD.n24 VDD.n23 4.5005
R20 VDD.n25 VDD.n16 4.5005
R21 VDD.n27 VDD.n26 4.5005
R22 VDD.n28 VDD.n15 4.5005
R23 VDD.n30 VDD.n29 4.5005
R24 VDD.n31 VDD.n14 4.5005
R25 VDD.n33 VDD.n32 4.5005
R26 VDD.n34 VDD.n13 4.5005
R27 VDD.n36 VDD.n35 4.5005
R28 VDD.n37 VDD.n12 4.5005
R29 VDD.n39 VDD.n38 4.5005
R30 VDD.n40 VDD.n11 4.5005
R31 VDD.n42 VDD.n41 4.5005
R32 VDD.n43 VDD.n10 4.5005
R33 VDD.n45 VDD.n44 4.5005
R34 VDD.n46 VDD.n9 4.5005
R35 VDD.n48 VDD.n47 4.5005
R36 VDD.n49 VDD.n8 4.5005
R37 VDD.n51 VDD.n50 4.5005
R38 VDD.n52 VDD.n7 4.5005
R39 VDD.n54 VDD.n53 4.5005
R40 VDD.n55 VDD.n6 4.5005
R41 VDD.n57 VDD.n56 4.5005
R42 VDD.n58 VDD.n5 4.5005
R43 VDD.n60 VDD.n59 4.5005
R44 VDD.n61 VDD.n4 4.5005
R45 VDD.n63 VDD.n62 4.5005
R46 VDD.n64 VDD.n3 4.5005
R47 VDD.n66 VDD.n65 4.5005
R48 VDD.n67 VDD.n2 4.5005
R49 VDD.n69 VDD.n68 4.5005
R50 VDD VDD.n70 0.821668
R51 VDD.n72 VDD.t2 0.546648
R52 VDD.n21 VDD.n20 0.494353
R53 VDD.n70 VDD.n1 0.440635
R54 VDD.n70 VDD.n69 0.246216
R55 VDD.n22 VDD.n21 0.167605
R56 VDD.n24 VDD.n17 0.0905
R57 VDD.n25 VDD.n24 0.0905
R58 VDD.n26 VDD.n25 0.0905
R59 VDD.n26 VDD.n15 0.0905
R60 VDD.n30 VDD.n15 0.0905
R61 VDD.n31 VDD.n30 0.0905
R62 VDD.n32 VDD.n31 0.0905
R63 VDD.n32 VDD.n13 0.0905
R64 VDD.n36 VDD.n13 0.0905
R65 VDD.n37 VDD.n36 0.0905
R66 VDD.n38 VDD.n37 0.0905
R67 VDD.n38 VDD.n11 0.0905
R68 VDD.n42 VDD.n11 0.0905
R69 VDD.n43 VDD.n42 0.0905
R70 VDD.n44 VDD.n43 0.0905
R71 VDD.n44 VDD.n9 0.0905
R72 VDD.n48 VDD.n9 0.0905
R73 VDD.n49 VDD.n48 0.0905
R74 VDD.n50 VDD.n49 0.0905
R75 VDD.n50 VDD.n7 0.0905
R76 VDD.n54 VDD.n7 0.0905
R77 VDD.n55 VDD.n54 0.0905
R78 VDD.n56 VDD.n55 0.0905
R79 VDD.n56 VDD.n5 0.0905
R80 VDD.n60 VDD.n5 0.0905
R81 VDD.n61 VDD.n60 0.0905
R82 VDD.n62 VDD.n61 0.0905
R83 VDD.n62 VDD.n3 0.0905
R84 VDD.n66 VDD.n3 0.0905
R85 VDD.n67 VDD.n66 0.0905
R86 VDD.n68 VDD.n67 0.0905
R87 VDD.n20 VDD.n17 0.0335
R88 VDD.n23 VDD.n22 0.0233814
R89 VDD.n23 VDD.n16 0.0233814
R90 VDD.n27 VDD.n16 0.0233814
R91 VDD.n28 VDD.n27 0.0233814
R92 VDD.n29 VDD.n28 0.0233814
R93 VDD.n29 VDD.n14 0.0233814
R94 VDD.n33 VDD.n14 0.0233814
R95 VDD.n34 VDD.n33 0.0233814
R96 VDD.n35 VDD.n34 0.0233814
R97 VDD.n35 VDD.n12 0.0233814
R98 VDD.n39 VDD.n12 0.0233814
R99 VDD.n40 VDD.n39 0.0233814
R100 VDD.n41 VDD.n40 0.0233814
R101 VDD.n41 VDD.n10 0.0233814
R102 VDD.n45 VDD.n10 0.0233814
R103 VDD.n46 VDD.n45 0.0233814
R104 VDD.n47 VDD.n46 0.0233814
R105 VDD.n47 VDD.n8 0.0233814
R106 VDD.n51 VDD.n8 0.0233814
R107 VDD.n52 VDD.n51 0.0233814
R108 VDD.n53 VDD.n52 0.0233814
R109 VDD.n53 VDD.n6 0.0233814
R110 VDD.n57 VDD.n6 0.0233814
R111 VDD.n58 VDD.n57 0.0233814
R112 VDD.n59 VDD.n58 0.0233814
R113 VDD.n59 VDD.n4 0.0233814
R114 VDD.n63 VDD.n4 0.0233814
R115 VDD.n64 VDD.n63 0.0233814
R116 VDD.n65 VDD.n64 0.0233814
R117 VDD.n65 VDD.n2 0.0233814
R118 VDD.n69 VDD.n2 0.0233814
R119 VDD.n68 VDD.n1 0.0125
R120 VSS.t1 VSS.n166 22187.7
R121 VSS.n165 VSS.n164 18727.5
R122 VSS.n164 VSS.t3 7638.22
R123 VSS.n169 VSS.n166 4092.47
R124 VSS.n164 VSS.n163 1140.34
R125 VSS.t5 VSS.t0 975
R126 VSS.t0 VSS.t1 975
R127 VSS.n169 VSS.t5 965.927
R128 VSS.t8 VSS.t10 834.404
R129 VSS.n163 VSS.t10 576.782
R130 VSS.t8 VSS.n169 547.577
R131 VSS.n163 VSS.t6 257.623
R132 VSS.n165 VSS.t4 74.9027
R133 VSS.n166 VSS.n165 35.4476
R134 VSS.n20 VSS.t2 11.753
R135 VSS.n97 VSS.t7 4.53915
R136 VSS.n162 VSS.n161 4.52338
R137 VSS.n143 VSS.n142 4.5005
R138 VSS.n144 VSS.n103 4.5005
R139 VSS.n146 VSS.n145 4.5005
R140 VSS.n147 VSS.n102 4.5005
R141 VSS.n149 VSS.n148 4.5005
R142 VSS.n150 VSS.n101 4.5005
R143 VSS.n152 VSS.n151 4.5005
R144 VSS.n153 VSS.n100 4.5005
R145 VSS.n155 VSS.n154 4.5005
R146 VSS.n156 VSS.n99 4.5005
R147 VSS.n158 VSS.n157 4.5005
R148 VSS.n159 VSS.n98 4.5005
R149 VSS.n161 VSS.n160 4.5005
R150 VSS.n121 VSS.n95 4.5005
R151 VSS.n123 VSS.n122 4.5005
R152 VSS.n120 VSS.n119 4.5005
R153 VSS.n127 VSS.n118 4.5005
R154 VSS.n128 VSS.n117 4.5005
R155 VSS.n129 VSS.n116 4.5005
R156 VSS.n115 VSS.n113 4.5005
R157 VSS.n133 VSS.n112 4.5005
R158 VSS.n134 VSS.n111 4.5005
R159 VSS.n135 VSS.n110 4.5005
R160 VSS.n106 VSS.n105 4.5005
R161 VSS.n140 VSS.n139 4.5005
R162 VSS.n141 VSS.n104 4.5005
R163 VSS.n267 VSS.n0 4.5005
R164 VSS.n268 VSS.n267 4.5005
R165 VSS.n266 VSS.n3 4.5005
R166 VSS.n260 VSS.n4 4.5005
R167 VSS.n262 VSS.n261 4.5005
R168 VSS.n259 VSS.n7 4.5005
R169 VSS.n258 VSS.n257 4.5005
R170 VSS.n11 VSS.n10 4.5005
R171 VSS.n253 VSS.n252 4.5005
R172 VSS.n251 VSS.n15 4.5005
R173 VSS.n250 VSS.n249 4.5005
R174 VSS.n19 VSS.n18 4.5005
R175 VSS.n245 VSS.n244 4.5005
R176 VSS.n243 VSS.n24 4.5005
R177 VSS.n242 VSS.n241 4.5005
R178 VSS.n28 VSS.n27 4.5005
R179 VSS.n237 VSS.n236 4.5005
R180 VSS.n235 VSS.n32 4.5005
R181 VSS.n234 VSS.n233 4.5005
R182 VSS.n36 VSS.n35 4.5005
R183 VSS.n229 VSS.n228 4.5005
R184 VSS.n227 VSS.n40 4.5005
R185 VSS.n226 VSS.n225 4.5005
R186 VSS.n43 VSS.n42 4.5005
R187 VSS.n221 VSS.n220 4.5005
R188 VSS.n219 VSS.n47 4.5005
R189 VSS.n218 VSS.n217 4.5005
R190 VSS.n51 VSS.n50 4.5005
R191 VSS.n213 VSS.n212 4.5005
R192 VSS.n211 VSS.n55 4.5005
R193 VSS.n210 VSS.n209 4.5005
R194 VSS.n59 VSS.n58 4.5005
R195 VSS.n205 VSS.n204 4.5005
R196 VSS.n203 VSS.n63 4.5005
R197 VSS.n202 VSS.n201 4.5005
R198 VSS.n67 VSS.n66 4.5005
R199 VSS.n197 VSS.n196 4.5005
R200 VSS.n195 VSS.n71 4.5005
R201 VSS.n194 VSS.n193 4.5005
R202 VSS.n75 VSS.n74 4.5005
R203 VSS.n189 VSS.n188 4.5005
R204 VSS.n187 VSS.n79 4.5005
R205 VSS.n186 VSS.n185 4.5005
R206 VSS.n83 VSS.n82 4.5005
R207 VSS.n181 VSS.n180 4.5005
R208 VSS.n179 VSS.n87 4.5005
R209 VSS.n178 VSS.n177 4.5005
R210 VSS.n91 VSS.n90 4.5005
R211 VSS.n173 VSS.n96 4.5005
R212 VSS.n173 VSS.n172 4.5005
R213 VSS.n170 VSS.n91 4.5005
R214 VSS.n177 VSS.n93 4.5005
R215 VSS.n92 VSS.n87 4.5005
R216 VSS.n181 VSS.n89 4.5005
R217 VSS.n88 VSS.n83 4.5005
R218 VSS.n185 VSS.n85 4.5005
R219 VSS.n84 VSS.n79 4.5005
R220 VSS.n189 VSS.n81 4.5005
R221 VSS.n80 VSS.n75 4.5005
R222 VSS.n193 VSS.n77 4.5005
R223 VSS.n76 VSS.n71 4.5005
R224 VSS.n197 VSS.n73 4.5005
R225 VSS.n72 VSS.n67 4.5005
R226 VSS.n201 VSS.n69 4.5005
R227 VSS.n68 VSS.n63 4.5005
R228 VSS.n205 VSS.n65 4.5005
R229 VSS.n64 VSS.n59 4.5005
R230 VSS.n209 VSS.n61 4.5005
R231 VSS.n60 VSS.n55 4.5005
R232 VSS.n213 VSS.n57 4.5005
R233 VSS.n56 VSS.n51 4.5005
R234 VSS.n217 VSS.n53 4.5005
R235 VSS.n52 VSS.n47 4.5005
R236 VSS.n221 VSS.n49 4.5005
R237 VSS.n48 VSS.n43 4.5005
R238 VSS.n225 VSS.n45 4.5005
R239 VSS.n44 VSS.n40 4.5005
R240 VSS.n229 VSS.n41 4.5005
R241 VSS.n167 VSS.n36 4.5005
R242 VSS.n233 VSS.n38 4.5005
R243 VSS.n37 VSS.n32 4.5005
R244 VSS.n237 VSS.n34 4.5005
R245 VSS.n33 VSS.n28 4.5005
R246 VSS.n241 VSS.n30 4.5005
R247 VSS.n29 VSS.n24 4.5005
R248 VSS.n245 VSS.n26 4.5005
R249 VSS.n25 VSS.n19 4.5005
R250 VSS.n249 VSS.n22 4.5005
R251 VSS.n21 VSS.n15 4.5005
R252 VSS.n253 VSS.n17 4.5005
R253 VSS.n16 VSS.n11 4.5005
R254 VSS.n257 VSS.n13 4.5005
R255 VSS.n12 VSS.n7 4.5005
R256 VSS.n262 VSS.n9 4.5005
R257 VSS.n8 VSS.n4 4.5005
R258 VSS.n266 VSS.n5 4.5005
R259 VSS.n267 VSS.n2 4.5005
R260 VSS.n266 VSS.n265 4.5005
R261 VSS.n264 VSS.n4 4.5005
R262 VSS.n263 VSS.n262 4.5005
R263 VSS.n7 VSS.n6 4.5005
R264 VSS.n257 VSS.n256 4.5005
R265 VSS.n255 VSS.n11 4.5005
R266 VSS.n254 VSS.n253 4.5005
R267 VSS.n15 VSS.n14 4.5005
R268 VSS.n249 VSS.n248 4.5005
R269 VSS.n247 VSS.n19 4.5005
R270 VSS.n246 VSS.n245 4.5005
R271 VSS.n24 VSS.n23 4.5005
R272 VSS.n241 VSS.n240 4.5005
R273 VSS.n239 VSS.n28 4.5005
R274 VSS.n238 VSS.n237 4.5005
R275 VSS.n32 VSS.n31 4.5005
R276 VSS.n233 VSS.n232 4.5005
R277 VSS.n231 VSS.n36 4.5005
R278 VSS.n230 VSS.n229 4.5005
R279 VSS.n40 VSS.n39 4.5005
R280 VSS.n225 VSS.n224 4.5005
R281 VSS.n223 VSS.n43 4.5005
R282 VSS.n222 VSS.n221 4.5005
R283 VSS.n47 VSS.n46 4.5005
R284 VSS.n217 VSS.n216 4.5005
R285 VSS.n215 VSS.n51 4.5005
R286 VSS.n214 VSS.n213 4.5005
R287 VSS.n55 VSS.n54 4.5005
R288 VSS.n209 VSS.n208 4.5005
R289 VSS.n207 VSS.n59 4.5005
R290 VSS.n206 VSS.n205 4.5005
R291 VSS.n63 VSS.n62 4.5005
R292 VSS.n201 VSS.n200 4.5005
R293 VSS.n199 VSS.n67 4.5005
R294 VSS.n198 VSS.n197 4.5005
R295 VSS.n71 VSS.n70 4.5005
R296 VSS.n193 VSS.n192 4.5005
R297 VSS.n191 VSS.n75 4.5005
R298 VSS.n190 VSS.n189 4.5005
R299 VSS.n79 VSS.n78 4.5005
R300 VSS.n185 VSS.n184 4.5005
R301 VSS.n183 VSS.n83 4.5005
R302 VSS.n182 VSS.n181 4.5005
R303 VSS.n87 VSS.n86 4.5005
R304 VSS.n177 VSS.n176 4.5005
R305 VSS.n175 VSS.n91 4.5005
R306 VSS.n174 VSS.n173 4.5005
R307 VSS.n95 VSS.n94 4.5005
R308 VSS.n124 VSS.n123 4.5005
R309 VSS.n125 VSS.n119 4.5005
R310 VSS.n127 VSS.n126 4.5005
R311 VSS.n128 VSS.n114 4.5005
R312 VSS.n130 VSS.n129 4.5005
R313 VSS.n131 VSS.n113 4.5005
R314 VSS.n133 VSS.n132 4.5005
R315 VSS.n134 VSS.n109 4.5005
R316 VSS.n136 VSS.n135 4.5005
R317 VSS.n137 VSS.n106 4.5005
R318 VSS.n139 VSS.n138 4.5005
R319 VSS.n108 VSS.n104 4.5005
R320 VSS.n107 VSS.t11 3.69605
R321 VSS.n171 VSS.t9 3.10066
R322 VSS.n107 VSS.t10 1.362
R323 VSS.n172 VSS.t8 1.3425
R324 VSS.t6 VSS.n162 1.3125
R325 VSS.n271 VSS.n1 1.07202
R326 VSS.n269 VSS.n1 0.846223
R327 VSS.n269 VSS.n268 0.24875
R328 VSS.t0 VSS.n168 0.24236
R329 VSS.n271 VSS.n270 0.220715
R330 VSS VSS.n271 0.202016
R331 VSS.n270 VSS.n269 0.107359
R332 VSS.n160 VSS.n159 0.0905
R333 VSS.n159 VSS.n158 0.0905
R334 VSS.n158 VSS.n99 0.0905
R335 VSS.n154 VSS.n99 0.0905
R336 VSS.n154 VSS.n153 0.0905
R337 VSS.n153 VSS.n152 0.0905
R338 VSS.n152 VSS.n101 0.0905
R339 VSS.n148 VSS.n101 0.0905
R340 VSS.n148 VSS.n147 0.0905
R341 VSS.n147 VSS.n146 0.0905
R342 VSS.n146 VSS.n103 0.0905
R343 VSS.n142 VSS.n103 0.0905
R344 VSS.n142 VSS.n141 0.0905
R345 VSS.n141 VSS.n140 0.0905
R346 VSS.n140 VSS.n105 0.0905
R347 VSS.n110 VSS.n105 0.0905
R348 VSS.n111 VSS.n110 0.0905
R349 VSS.n112 VSS.n111 0.0905
R350 VSS.n115 VSS.n112 0.0905
R351 VSS.n116 VSS.n115 0.0905
R352 VSS.n117 VSS.n116 0.0905
R353 VSS.n118 VSS.n117 0.0905
R354 VSS.n120 VSS.n118 0.0905
R355 VSS.n122 VSS.n120 0.0905
R356 VSS.n122 VSS.n121 0.0905
R357 VSS.n121 VSS.n96 0.0905
R358 VSS.n96 VSS.n90 0.0905
R359 VSS.n178 VSS.n90 0.0905
R360 VSS.n179 VSS.n178 0.0905
R361 VSS.n180 VSS.n179 0.0905
R362 VSS.n180 VSS.n82 0.0905
R363 VSS.n186 VSS.n82 0.0905
R364 VSS.n187 VSS.n186 0.0905
R365 VSS.n188 VSS.n187 0.0905
R366 VSS.n188 VSS.n74 0.0905
R367 VSS.n194 VSS.n74 0.0905
R368 VSS.n195 VSS.n194 0.0905
R369 VSS.n196 VSS.n195 0.0905
R370 VSS.n196 VSS.n66 0.0905
R371 VSS.n202 VSS.n66 0.0905
R372 VSS.n203 VSS.n202 0.0905
R373 VSS.n204 VSS.n203 0.0905
R374 VSS.n204 VSS.n58 0.0905
R375 VSS.n210 VSS.n58 0.0905
R376 VSS.n211 VSS.n210 0.0905
R377 VSS.n212 VSS.n211 0.0905
R378 VSS.n212 VSS.n50 0.0905
R379 VSS.n218 VSS.n50 0.0905
R380 VSS.n219 VSS.n218 0.0905
R381 VSS.n220 VSS.n219 0.0905
R382 VSS.n220 VSS.n42 0.0905
R383 VSS.n226 VSS.n42 0.0905
R384 VSS.n227 VSS.n226 0.0905
R385 VSS.n228 VSS.n227 0.0905
R386 VSS.n228 VSS.n35 0.0905
R387 VSS.n234 VSS.n35 0.0905
R388 VSS.n235 VSS.n234 0.0905
R389 VSS.n236 VSS.n235 0.0905
R390 VSS.n236 VSS.n27 0.0905
R391 VSS.n242 VSS.n27 0.0905
R392 VSS.n243 VSS.n242 0.0905
R393 VSS.n244 VSS.n243 0.0905
R394 VSS.n244 VSS.n18 0.0905
R395 VSS.n250 VSS.n18 0.0905
R396 VSS.n251 VSS.n250 0.0905
R397 VSS.n252 VSS.n251 0.0905
R398 VSS.n252 VSS.n10 0.0905
R399 VSS.n258 VSS.n10 0.0905
R400 VSS.n259 VSS.n258 0.0905
R401 VSS.n261 VSS.n259 0.0905
R402 VSS.n261 VSS.n260 0.0905
R403 VSS.n260 VSS.n3 0.0905
R404 VSS.n268 VSS.n3 0.0905
R405 VSS.n170 VSS.n93 0.0905
R406 VSS.n93 VSS.n92 0.0905
R407 VSS.n92 VSS.n89 0.0905
R408 VSS.n89 VSS.n88 0.0905
R409 VSS.n88 VSS.n85 0.0905
R410 VSS.n85 VSS.n84 0.0905
R411 VSS.n84 VSS.n81 0.0905
R412 VSS.n81 VSS.n80 0.0905
R413 VSS.n80 VSS.n77 0.0905
R414 VSS.n77 VSS.n76 0.0905
R415 VSS.n76 VSS.n73 0.0905
R416 VSS.n138 VSS.n108 0.0905
R417 VSS.n138 VSS.n137 0.0905
R418 VSS.n137 VSS.n136 0.0905
R419 VSS.n136 VSS.n109 0.0905
R420 VSS.n132 VSS.n109 0.0905
R421 VSS.n132 VSS.n131 0.0905
R422 VSS.n131 VSS.n130 0.0905
R423 VSS.n130 VSS.n114 0.0905
R424 VSS.n126 VSS.n114 0.0905
R425 VSS.n126 VSS.n125 0.0905
R426 VSS.n125 VSS.n124 0.0905
R427 VSS.n124 VSS.n94 0.0905
R428 VSS.n174 VSS.n94 0.0905
R429 VSS.n175 VSS.n174 0.0905
R430 VSS.n176 VSS.n175 0.0905
R431 VSS.n176 VSS.n86 0.0905
R432 VSS.n182 VSS.n86 0.0905
R433 VSS.n183 VSS.n182 0.0905
R434 VSS.n184 VSS.n183 0.0905
R435 VSS.n184 VSS.n78 0.0905
R436 VSS.n190 VSS.n78 0.0905
R437 VSS.n191 VSS.n190 0.0905
R438 VSS.n192 VSS.n191 0.0905
R439 VSS.n192 VSS.n70 0.0905
R440 VSS.n198 VSS.n70 0.0905
R441 VSS.n199 VSS.n198 0.0905
R442 VSS.n200 VSS.n199 0.0905
R443 VSS.n200 VSS.n62 0.0905
R444 VSS.n206 VSS.n62 0.0905
R445 VSS.n207 VSS.n206 0.0905
R446 VSS.n208 VSS.n207 0.0905
R447 VSS.n208 VSS.n54 0.0905
R448 VSS.n214 VSS.n54 0.0905
R449 VSS.n215 VSS.n214 0.0905
R450 VSS.n216 VSS.n215 0.0905
R451 VSS.n216 VSS.n46 0.0905
R452 VSS.n222 VSS.n46 0.0905
R453 VSS.n223 VSS.n222 0.0905
R454 VSS.n224 VSS.n223 0.0905
R455 VSS.n224 VSS.n39 0.0905
R456 VSS.n230 VSS.n39 0.0905
R457 VSS.n231 VSS.n230 0.0905
R458 VSS.n232 VSS.n231 0.0905
R459 VSS.n232 VSS.n31 0.0905
R460 VSS.n238 VSS.n31 0.0905
R461 VSS.n239 VSS.n238 0.0905
R462 VSS.n240 VSS.n239 0.0905
R463 VSS.n240 VSS.n23 0.0905
R464 VSS.n246 VSS.n23 0.0905
R465 VSS.n247 VSS.n246 0.0905
R466 VSS.n248 VSS.n247 0.0905
R467 VSS.n248 VSS.n14 0.0905
R468 VSS.n254 VSS.n14 0.0905
R469 VSS.n255 VSS.n254 0.0905
R470 VSS.n256 VSS.n255 0.0905
R471 VSS.n256 VSS.n6 0.0905
R472 VSS.n263 VSS.n6 0.0905
R473 VSS.n264 VSS.n263 0.0905
R474 VSS.n265 VSS.n264 0.0905
R475 VSS.n265 VSS.n2 0.0905
R476 VSS.n73 VSS.n72 0.0813125
R477 VSS.n5 VSS.n0 0.0798125
R478 VSS.n272 VSS.n0 0.0785
R479 VSS.n270 VSS.n2 0.0785
R480 VSS.n171 VSS.n170 0.071
R481 VSS.n72 VSS.n69 0.068
R482 VSS.n69 VSS.n68 0.068
R483 VSS.n68 VSS.n65 0.068
R484 VSS.n65 VSS.n64 0.068
R485 VSS.n64 VSS.n61 0.068
R486 VSS.n61 VSS.n60 0.068
R487 VSS.n60 VSS.n57 0.068
R488 VSS.n57 VSS.n56 0.068
R489 VSS.n56 VSS.n53 0.068
R490 VSS.n53 VSS.n52 0.068
R491 VSS.n52 VSS.n49 0.068
R492 VSS.n49 VSS.n48 0.068
R493 VSS.n48 VSS.n45 0.068
R494 VSS.n45 VSS.n44 0.068
R495 VSS.n44 VSS.n41 0.068
R496 VSS.n167 VSS.n41 0.068
R497 VSS.n38 VSS.n37 0.068
R498 VSS.n37 VSS.n34 0.068
R499 VSS.n34 VSS.n33 0.068
R500 VSS.n33 VSS.n30 0.068
R501 VSS.n30 VSS.n29 0.068
R502 VSS.n29 VSS.n26 0.068
R503 VSS.n26 VSS.n25 0.068
R504 VSS.n25 VSS.n22 0.068
R505 VSS.n22 VSS.n21 0.068
R506 VSS.n17 VSS.n16 0.068
R507 VSS.n16 VSS.n13 0.068
R508 VSS.n13 VSS.n12 0.068
R509 VSS.n12 VSS.n9 0.068
R510 VSS.n9 VSS.n8 0.068
R511 VSS.n8 VSS.n5 0.068
R512 VSS.n162 VSS.n97 0.05
R513 VSS VSS.n272 0.0455
R514 VSS.n160 VSS.n97 0.041
R515 VSS.n168 VSS.n167 0.0365
R516 VSS.n21 VSS.n20 0.0365
R517 VSS.n168 VSS.n38 0.032
R518 VSS.n20 VSS.n17 0.032
R519 VSS.n161 VSS.n98 0.0233814
R520 VSS.n157 VSS.n98 0.0233814
R521 VSS.n157 VSS.n156 0.0233814
R522 VSS.n156 VSS.n155 0.0233814
R523 VSS.n155 VSS.n100 0.0233814
R524 VSS.n151 VSS.n100 0.0233814
R525 VSS.n151 VSS.n150 0.0233814
R526 VSS.n150 VSS.n149 0.0233814
R527 VSS.n149 VSS.n102 0.0233814
R528 VSS.n145 VSS.n102 0.0233814
R529 VSS.n145 VSS.n144 0.0233814
R530 VSS.n144 VSS.n143 0.0233814
R531 VSS.n172 VSS.n171 0.02
R532 VSS.n143 VSS.n104 0.0142288
R533 VSS.n139 VSS.n104 0.0119407
R534 VSS.n139 VSS.n106 0.0119407
R535 VSS.n135 VSS.n106 0.0119407
R536 VSS.n135 VSS.n134 0.0119407
R537 VSS.n134 VSS.n133 0.0119407
R538 VSS.n133 VSS.n113 0.0119407
R539 VSS.n129 VSS.n113 0.0119407
R540 VSS.n129 VSS.n128 0.0119407
R541 VSS.n128 VSS.n127 0.0119407
R542 VSS.n127 VSS.n119 0.0119407
R543 VSS.n123 VSS.n119 0.0119407
R544 VSS.n123 VSS.n95 0.0119407
R545 VSS.n108 VSS.n107 0.011
R546 VSS.n173 VSS.n95 0.010161
R547 VSS.n173 VSS.n91 0.00812712
R548 VSS.n177 VSS.n91 0.00812712
R549 VSS.n177 VSS.n87 0.00812712
R550 VSS.n181 VSS.n87 0.00812712
R551 VSS.n181 VSS.n83 0.00812712
R552 VSS.n185 VSS.n83 0.00812712
R553 VSS.n185 VSS.n79 0.00812712
R554 VSS.n189 VSS.n79 0.00812712
R555 VSS.n189 VSS.n75 0.00812712
R556 VSS.n193 VSS.n75 0.00812712
R557 VSS.n193 VSS.n71 0.00812712
R558 VSS.n197 VSS.n71 0.00812712
R559 VSS.n197 VSS.n67 0.00812712
R560 VSS.n201 VSS.n67 0.00812712
R561 VSS.n201 VSS.n63 0.00812712
R562 VSS.n205 VSS.n63 0.00812712
R563 VSS.n205 VSS.n59 0.00812712
R564 VSS.n209 VSS.n59 0.00812712
R565 VSS.n209 VSS.n55 0.00812712
R566 VSS.n213 VSS.n55 0.00812712
R567 VSS.n213 VSS.n51 0.00812712
R568 VSS.n217 VSS.n51 0.00812712
R569 VSS.n217 VSS.n47 0.00812712
R570 VSS.n221 VSS.n47 0.00812712
R571 VSS.n221 VSS.n43 0.00812712
R572 VSS.n225 VSS.n43 0.00812712
R573 VSS.n225 VSS.n40 0.00812712
R574 VSS.n229 VSS.n40 0.00812712
R575 VSS.n229 VSS.n36 0.00812712
R576 VSS.n233 VSS.n36 0.00812712
R577 VSS.n233 VSS.n32 0.00812712
R578 VSS.n237 VSS.n32 0.00812712
R579 VSS.n237 VSS.n28 0.00812712
R580 VSS.n241 VSS.n28 0.00812712
R581 VSS.n241 VSS.n24 0.00812712
R582 VSS.n245 VSS.n24 0.00812712
R583 VSS.n245 VSS.n19 0.00812712
R584 VSS.n249 VSS.n19 0.00812712
R585 VSS.n249 VSS.n15 0.00812712
R586 VSS.n253 VSS.n15 0.00812712
R587 VSS.n253 VSS.n11 0.00812712
R588 VSS.n257 VSS.n11 0.00812712
R589 VSS.n257 VSS.n7 0.00812712
R590 VSS.n262 VSS.n7 0.00812712
R591 VSS.n262 VSS.n4 0.00812712
R592 VSS.n266 VSS.n4 0.00812712
R593 VSS.n267 VSS.n266 0.00812712
R594 VSS.n272 VSS 0.008
R595 VSS.n267 VSS.n1 0.00711017
R596 a_100_n800.t0 a_100_n800.n0 11.8864
R597 a_100_n800.n0 a_100_n800.t1 17.1417
R598 a_100_n800.n0 a_100_n800.t2 13.815
R599 a_2430_n800.t0 a_2430_n800.n0 19.9355
R600 a_2430_n800.n0 a_2430_n800.t2 0.626128
R601 a_2430_n800.n0 a_2430_n800.t1 21.5172
R602 a_938_3424.t0 a_938_3424.n0 19.6007
R603 a_938_3424.n0 a_938_3424.n1 0.693179
R604 a_938_3424.n1 a_938_3424.t3 159.727
R605 a_938_3424.n1 a_938_3424.t1 157.845
R606 a_938_3424.n0 a_938_3424.t2 15.458
R607 a_8030_n1600.t0 a_8030_n1600.n0 23.415
R608 a_8030_n1600.n0 a_8030_n1600.t1 21.4021
R609 a_8030_n1600.n0 a_8030_n1600.t2 28.2014
R610 a_2156_7176.t0 a_2156_7176.n0 22.7079
R611 a_2156_7176.n0 a_2156_7176.t1 15.5022
R612 a_2156_7176.n0 a_2156_7176.t2 15.4145
R613 a_2156_7176.n0 a_2156_7176.n1 15.6493
R614 a_2156_7176.n1 a_2156_7176.t3 202.025
R615 a_2156_7176.n1 a_2156_7176.t4 378.755
R616 a_1676_7176.t0 a_1676_7176.t1 18.4426
R617 a_1676_7176.t1 a_1676_7176.n0 11.5398
R618 a_1676_7176.n0 a_1676_7176.t2 119.855
R619 a_1676_7176.n0 a_1676_7176.t3 175.95
R620 a_6430_n1100.t1 a_6430_n1100.n0 18.669
R621 a_6430_n1100.n0 a_6430_n1100.t0 20.8513
R622 a_6430_n1100.n0 a_6430_n1100.n1 15.6493
R623 a_6430_n1100.n1 a_6430_n1100.t2 265.752
R624 a_6430_n1100.n1 a_6430_n1100.t3 600.648
C7 INM VSS 0.73625f
C8 INP VSS 0.72362f
C9 IBIAS VSS 1.12052f
C10 OUT VSS 0.52991f
C11 VDD VSS 0.12013p
C12 m1_3129_7189# VSS 0.17907f
C13 a_6430_n1100.t1 VSS 1.20933f $ **FLOATING
C14 a_6430_n1100.n0 VSS 1.67989f $ **FLOATING
C15 a_6430_n1100.t3 VSS 1.42069f $ **FLOATING
C16 a_6430_n1100.t2 VSS 0.55371f $ **FLOATING
C17 a_6430_n1100.n1 VSS 3.23427f $ **FLOATING
C18 a_6430_n1100.t0 VSS 2.47039f $ **FLOATING
C19 a_1676_7176.t0 VSS 0.10143f $ **FLOATING
C20 a_1676_7176.t1 VSS 2.60005f $ **FLOATING
C21 a_1676_7176.t3 VSS 0.20899f $ **FLOATING
C22 a_1676_7176.t2 VSS 0.11833f $ **FLOATING
C23 a_1676_7176.n0 VSS 0.84158f $ **FLOATING
C24 a_2156_7176.t0 VSS 0.372f $ **FLOATING
C25 a_2156_7176.n0 VSS 1.82933f $ **FLOATING
C26 a_2156_7176.t4 VSS 0.73935f $ **FLOATING
C27 a_2156_7176.t3 VSS 0.33564f $ **FLOATING
C28 a_2156_7176.n1 VSS 1.98328f $ **FLOATING
C29 a_2156_7176.t2 VSS 0.83514f $ **FLOATING
C30 a_2156_7176.t1 VSS 0.42149f $ **FLOATING
C31 a_8030_n1600.t0 VSS 0.25228f $ **FLOATING
C32 a_8030_n1600.t2 VSS 4.68093f $ **FLOATING
C33 a_8030_n1600.t1 VSS 1.93043f $ **FLOATING
C34 a_8030_n1600.n0 VSS 2.5583f $ **FLOATING
C35 a_938_3424.t0 VSS 1.01975f $ **FLOATING
C36 a_938_3424.n0 VSS 0.68752f $ **FLOATING
C37 a_938_3424.t2 VSS 0.88495f $ **FLOATING
C38 a_938_3424.n1 VSS 0.80167f $ **FLOATING
C39 a_938_3424.t1 VSS 0.34707f $ **FLOATING
C40 a_938_3424.t3 VSS 0.35152f $ **FLOATING
C41 a_2430_n800.t0 VSS 0.19954f $ **FLOATING
C42 a_2430_n800.t1 VSS 0.22115f $ **FLOATING
C43 a_2430_n800.t2 VSS 3.06686f $ **FLOATING
C44 a_2430_n800.n0 VSS 0.47708f $ **FLOATING
C45 a_100_n800.t0 VSS 0.42751f $ **FLOATING
C46 a_100_n800.t2 VSS 0.44606f $ **FLOATING
C47 a_100_n800.t1 VSS 0.49891f $ **FLOATING
C48 a_100_n800.n0 VSS 0.58207f $ **FLOATING
C49 VDD.t7 VSS 0.1962f $ **FLOATING
C50 VDD.t6 VSS 1.37579f $ **FLOATING
C51 VDD.n0 VSS 0.80389f $ **FLOATING
C52 VDD.n1 VSS 0.29691f $ **FLOATING
C53 VDD.n2 VSS 0.03173f $ **FLOATING
C54 VDD.n3 VSS 0.00807f $ **FLOATING
C55 VDD.n4 VSS 0.03173f $ **FLOATING
C56 VDD.n5 VSS 0.00807f $ **FLOATING
C57 VDD.n6 VSS 0.03173f $ **FLOATING
C58 VDD.n7 VSS 0.00807f $ **FLOATING
C59 VDD.n8 VSS 0.03173f $ **FLOATING
C60 VDD.n9 VSS 0.00807f $ **FLOATING
C61 VDD.n10 VSS 0.03173f $ **FLOATING
C62 VDD.n11 VSS 0.00807f $ **FLOATING
C63 VDD.n12 VSS 0.03173f $ **FLOATING
C64 VDD.n13 VSS 0.00807f $ **FLOATING
C65 VDD.n14 VSS 0.03173f $ **FLOATING
C66 VDD.n15 VSS 0.00807f $ **FLOATING
C67 VDD.n16 VSS 0.03173f $ **FLOATING
C68 VDD.n17 VSS 0.00551f $ **FLOATING
C69 VDD.t5 VSS 0.77525f $ **FLOATING
C70 VDD.t4 VSS 4.80425f $ **FLOATING
C71 VDD.n18 VSS 2.27137f $ **FLOATING
C72 VDD.t9 VSS 0.47131f $ **FLOATING
C73 VDD.t8 VSS 2.98917f $ **FLOATING
C74 VDD.n19 VSS 1.45859f $ **FLOATING
C75 VDD.n20 VSS 0.36583f $ **FLOATING
C76 VDD.n21 VSS 1.39539f $ **FLOATING
C77 VDD.n22 VSS 0.26273f $ **FLOATING
C78 VDD.n23 VSS 0.03173f $ **FLOATING
C79 VDD.n24 VSS 0.00807f $ **FLOATING
C80 VDD.n25 VSS 0.00807f $ **FLOATING
C81 VDD.n26 VSS 0.00807f $ **FLOATING
C82 VDD.n27 VSS 0.03173f $ **FLOATING
C83 VDD.n28 VSS 0.03173f $ **FLOATING
C84 VDD.n29 VSS 0.03173f $ **FLOATING
C85 VDD.n30 VSS 0.00807f $ **FLOATING
C86 VDD.n31 VSS 0.00807f $ **FLOATING
C87 VDD.n32 VSS 0.00807f $ **FLOATING
C88 VDD.n33 VSS 0.03173f $ **FLOATING
C89 VDD.n34 VSS 0.03173f $ **FLOATING
C90 VDD.n35 VSS 0.03173f $ **FLOATING
C91 VDD.n36 VSS 0.00807f $ **FLOATING
C92 VDD.n37 VSS 0.00807f $ **FLOATING
C93 VDD.n38 VSS 0.00807f $ **FLOATING
C94 VDD.n39 VSS 0.03173f $ **FLOATING
C95 VDD.n40 VSS 0.03173f $ **FLOATING
C96 VDD.n41 VSS 0.03173f $ **FLOATING
C97 VDD.n42 VSS 0.00807f $ **FLOATING
C98 VDD.n43 VSS 0.00807f $ **FLOATING
C99 VDD.n44 VSS 0.00807f $ **FLOATING
C100 VDD.n45 VSS 0.03173f $ **FLOATING
C101 VDD.n46 VSS 0.03173f $ **FLOATING
C102 VDD.n47 VSS 0.03173f $ **FLOATING
C103 VDD.n48 VSS 0.00807f $ **FLOATING
C104 VDD.n49 VSS 0.00807f $ **FLOATING
C105 VDD.n50 VSS 0.00807f $ **FLOATING
C106 VDD.n51 VSS 0.03173f $ **FLOATING
C107 VDD.n52 VSS 0.03173f $ **FLOATING
C108 VDD.n53 VSS 0.03173f $ **FLOATING
C109 VDD.n54 VSS 0.00807f $ **FLOATING
C110 VDD.n55 VSS 0.00807f $ **FLOATING
C111 VDD.n56 VSS 0.00807f $ **FLOATING
C112 VDD.n57 VSS 0.03173f $ **FLOATING
C113 VDD.n58 VSS 0.03173f $ **FLOATING
C114 VDD.n59 VSS 0.03173f $ **FLOATING
C115 VDD.n60 VSS 0.00807f $ **FLOATING
C116 VDD.n61 VSS 0.00807f $ **FLOATING
C117 VDD.n62 VSS 0.00807f $ **FLOATING
C118 VDD.n63 VSS 0.03173f $ **FLOATING
C119 VDD.n64 VSS 0.03173f $ **FLOATING
C120 VDD.n65 VSS 0.03173f $ **FLOATING
C121 VDD.n66 VSS 0.00807f $ **FLOATING
C122 VDD.n67 VSS 0.00807f $ **FLOATING
C123 VDD.n68 VSS 0.00457f $ **FLOATING
C124 VDD.n69 VSS 0.41325f $ **FLOATING
C125 VDD.n70 VSS 0.3241f $ **FLOATING
C126 VDD.t0 VSS 2.15121f $ **FLOATING
C127 VDD.t2 VSS 3.76597f $ **FLOATING
C128 VDD.t1 VSS 0.11935f $ **FLOATING
C129 VDD.t3 VSS 0.11165f $ **FLOATING
C130 VDD.n71 VSS 0.107f $ **FLOATING
C131 VDD.n72 VSS 0.21759f $ **FLOATING
C132 OUT.t0 VSS 0.02581f $ **FLOATING
C133 IBIAS.t0 VSS 0.30151f $ **FLOATING
C134 INP.t0 VSS 0.15981f $ **FLOATING
C135 INM.t0 VSS 0.15036f $ **FLOATING
.ends ib_conv_v1_pex
