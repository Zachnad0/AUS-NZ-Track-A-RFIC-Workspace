* ib_conv_v1_pex -- flat R+C PEX wrapped as a subckt.
* External terminals are the bare port-label nodes (rule: exact port-label name):
*   IBIAS INP INM OUT VDD VSS. All VDD.tN / VSS.tN / VSS.nNNN stay INTERNAL and are
*   NOT tied together -- tying them would short out the extracted bus resistance.
* Generated with ext2spice scale off, so dimensions are absolute and mix with the
*   absolute-unit DIV2 bench. The committed .pex.spice carries .option scale=5n and
*   is NOT mixable.
.subckt ib_conv_v1_pex_nor IBIAS INP INM OUT VDD VSS
X0 a_938_3424.t1 INP a_100_n800.t0 VSS nfet_03v3 ad=3.52p pd=16.88u as=3.52p ps=16.88u w=8u l=0.3u
X1 a_938_3424.t1 a_938_3424.t1 VDD VDD pfet_03v3 ad=3.52p pd=16.88u as=3.52p ps=16.88u w=8u l=0.3u
X2 a_8030_n1600.t1 a_6430_n1100.t1 VDD VDD pfet_03v3 ad=19.36p pd=88.88u as=19.36p ps=88.88u w=44u l=0.3u
X3 a_8030_n1600.t1 a_6430_n1100.t1 VSS VSS nfet_03v3 ad=7.04p pd=32.88u as=7.04p ps=32.88u w=16u l=0.3u
X4 a_6430_n1100.t1 a_2156_7176.t2 VDD VDD pfet_03v3 ad=11.44p pd=52.88u as=11.44p ps=52.88u w=26u l=0.3u
X5 a_2430_n800.t0 INM a_100_n800.t0 VSS nfet_03v3 ad=3.52p pd=16.88u as=3.52p ps=16.88u w=8u l=0.3u
X6 a_6430_n1100.t1 a_2156_7176.t2 VSS VSS nfet_03v3 ad=4.84p pd=22.88u as=4.84p ps=22.88u w=11u l=0.3u
X7 OUT a_8030_n1600.t1 VSS ppolyf_u_1k r_width=2u r_length=2u
X8 a_2156_7176.t2 a_1676_7176.t0 VSS VSS nfet_03v3 ad=1.76p pd=8.88u as=1.76p ps=8.88u w=4u l=0.3u
X9 a_100_n800.t0 IBIAS VSS VSS nfet_03v3 ad=3.52p pd=16.88u as=3.52p ps=16.88u w=8u l=1u
X10 a_2156_7176.t2 a_1676_7176.t0 VDD VDD pfet_03v3 ad=4.4p pd=20.88u as=4.4p ps=20.88u w=10u l=0.3u
X11 a_2430_n800.t0 a_938_3424.t1 VDD VDD pfet_03v3 ad=3.52p pd=16.88u as=3.52p ps=16.88u w=8u l=0.3u
X12 a_2430_n800.t0 a_1676_7176.t0 cap_mim_2f0_m4m5_noshield c_width=5u c_length=10u
X13 a_2156_7176.t2 a_1676_7176.t0 VSS ppolyf_u_1k r_width=2u r_length=40.04u
C0 INM INP 0.0187f
C1 INP VDD 0.03938f
C2 m1_3129_7189# VDD 0.00196f
C3 OUT VDD 0.0071f
C4 INM VDD 0.03938f
C5 IBIAS INP 0.01831f
C6 IBIAS VDD 0.05655f
C7 INM VSS 0.73625f
C8 INP VSS 0.72362f
C9 IBIAS VSS 1.12052f
C10 OUT VSS 0.52991f
C11 VDD VSS 0.11595p
C12 m1_3129_7189# VSS 0.17907f
C13 a_6430_n1100.t1 VSS 1.20933f $ **FLOATING
C14 a_6430_n1100.t1 VSS 1.6799f $ **FLOATING
C15 a_6430_n1100.t1 VSS 1.42069f $ **FLOATING
C16 a_6430_n1100.t1 VSS 0.55371f $ **FLOATING
C17 a_6430_n1100.t1 VSS 3.23427f $ **FLOATING
C18 a_6430_n1100.t1 VSS 2.47039f $ **FLOATING
C19 a_1676_7176.t0 VSS 0.10143f $ **FLOATING
C20 a_1676_7176.t0 VSS 2.60005f $ **FLOATING
C21 a_1676_7176.t0 VSS 0.20899f $ **FLOATING
C22 a_1676_7176.t0 VSS 0.11833f $ **FLOATING
C23 a_1676_7176.t0 VSS 0.84158f $ **FLOATING
C24 a_2156_7176.t2 VSS 0.372f $ **FLOATING
C25 a_2156_7176.t2 VSS 1.82933f $ **FLOATING
C26 a_2156_7176.t2 VSS 0.73935f $ **FLOATING
C27 a_2156_7176.t2 VSS 0.33564f $ **FLOATING
C28 a_2156_7176.t2 VSS 1.98328f $ **FLOATING
C29 a_2156_7176.t2 VSS 0.83514f $ **FLOATING
C30 a_2156_7176.t2 VSS 0.42149f $ **FLOATING
C31 a_8030_n1600.t1 VSS 0.25228f $ **FLOATING
C32 a_8030_n1600.t1 VSS 4.68093f $ **FLOATING
C33 a_8030_n1600.t1 VSS 1.93043f $ **FLOATING
C34 a_8030_n1600.t1 VSS 2.5583f $ **FLOATING
C35 a_938_3424.t1 VSS 0.88495f $ **FLOATING
C36 a_938_3424.t1 VSS 1.01975f $ **FLOATING
C37 a_938_3424.t1 VSS 0.68752f $ **FLOATING
C38 a_938_3424.t1 VSS 0.80167f $ **FLOATING
C39 a_938_3424.t1 VSS 0.34707f $ **FLOATING
C40 a_938_3424.t1 VSS 0.35152f $ **FLOATING
C41 a_2430_n800.t0 VSS 0.19954f $ **FLOATING
C42 a_2430_n800.t0 VSS 0.22115f $ **FLOATING
C43 a_2430_n800.t0 VSS 3.06686f $ **FLOATING
C44 a_2430_n800.t0 VSS 0.47708f $ **FLOATING
C45 a_100_n800.t0 VSS 0.44606f $ **FLOATING
C46 a_100_n800.t0 VSS 0.42751f $ **FLOATING
C47 a_100_n800.t0 VSS 0.58207f $ **FLOATING
C48 a_100_n800.t0 VSS 0.49891f $ **FLOATING
C49 VDD VSS 0.86955f $ **FLOATING
C50 VDD VSS 5.38861f $ **FLOATING
C51 VDD VSS 2.51749f $ **FLOATING
C52 VDD VSS 0.52864f $ **FLOATING
C53 VDD VSS 3.35276f $ **FLOATING
C54 VDD VSS 1.56678f $ **FLOATING
C55 VDD VSS 1.22793f $ **FLOATING
C56 VDD VSS 0.22006f $ **FLOATING
C57 VDD VSS 1.54313f $ **FLOATING
C58 VDD VSS 0.84259f $ **FLOATING
C59 VDD VSS 0.57789f $ **FLOATING
C60 VDD VSS 2.41287f $ **FLOATING
C61 VDD VSS 4.22404f $ **FLOATING
C62 VDD VSS 0.13386f $ **FLOATING
C63 VDD VSS 0.12523f $ **FLOATING
C64 VDD VSS 0.12002f $ **FLOATING
C65 VDD VSS 0.24406f $ **FLOATING
C66 OUT VSS 0.02581f $ **FLOATING
C67 IBIAS VSS 0.30151f $ **FLOATING
C68 INP VSS 0.15981f $ **FLOATING
C69 INM VSS 0.15036f $ **FLOATING
.ends ib_conv_v1_pex_nor
