* NGSPICE file created from CP_v1_flat.ext - technology: gf180mcuD

.option scale=5n

X0 CP_OUT.t4 UPB.t11 PMID.t2 VDD.t2 pfet_03v3 ad=52n pd=1.104m as=88n ps=2.176m w=1000 l=60
X1 UPB.t1 UP.t0 VSS.t3 VSS.t2 nfet_03v3 ad=17.6n pd=0.576m as=17.6n ps=0.576m w=200 l=60
X2 PMID.t0 UPB.t2 CP_OUT.t0 VDD.t0 pfet_03v3 ad=88n pd=2.176m as=52n ps=1.104m w=1000 l=60
X3 VGN.t3 VGN.t2 VSS.t7 VSS.t6 nfet_03v3 ad=52n pd=1.104m as=88n ps=2.176m w=1000 l=400
X4 VSS.t5 VGN.t4 NMID.t3 VSS.t4 nfet_03v3 ad=88n pd=2.176m as=52n ps=1.104m w=1000 l=400
X5 NMID.t2 VGN.t5 VSS.t11 VSS.t10 nfet_03v3 ad=52n pd=1.104m as=52n ps=1.104m w=1000 l=400
X6 VDD.t9 VGP.t22 PMID.t13 VDD.t8 pfet_03v3 ad=52n pd=1.104m as=52n ps=1.104m w=1000 l=400
X7 CP_OUT.t1 DOWN.t1 NMID.t0 VSS.t0 nfet_03v3 ad=52n pd=1.104m as=88n ps=2.176m w=1000 l=60
X8 UPB.t0 UP.t1 VDD.t5 VDD.t4 pfet_03v3 ad=35.2n pd=0.976m as=35.2n ps=0.976m w=400 l=60
X9 CP_OUT.t7 UPB.t3 PMID.t5 VDD.t7 pfet_03v3 ad=52n pd=1.104m as=52n ps=1.104m w=1000 l=60
X10 VGP.t13 VGP.t12 VDD.t37 VDD.t36 pfet_03v3 ad=52n pd=1.104m as=52n ps=1.104m w=1000 l=400
X11 VDD.t47 VGP.t20 PMID.t15 VDD.t46 pfet_03v3 ad=88n pd=2.176m as=52n ps=1.104m w=1000 l=400
X12 VDD.t39 VGP.t2 VGP.t3 VDD.t38 pfet_03v3 ad=52n pd=1.104m as=52n ps=1.104m w=1000 l=400
X13 PMID.t10 VGP.t25 VDD.t31 VDD.t30 pfet_03v3 ad=52n pd=1.104m as=52n ps=1.104m w=1000 l=400
X14 CP_OUT.t6 UPB.t5 PMID.t4 VDD.t6 pfet_03v3 ad=52n pd=1.104m as=52n ps=1.104m w=1000 l=60
X15 CP_OUT.t9 UPB.t7 PMID.t17 VDD.t49 pfet_03v3 ad=52n pd=1.104m as=52n ps=1.104m w=1000 l=60
X16 VGP.t11 VGP.t10 VDD.t41 VDD.t40 pfet_03v3 ad=52n pd=1.104m as=52n ps=1.104m w=1000 l=400
X17 NMID.t1 DOWN.t0 CP_OUT.t2 VSS.t1 nfet_03v3 ad=88n pd=2.176m as=52n ps=1.104m w=1000 l=60
X18 PMID.t6 VGP.t29 VDD.t17 VDD.t16 pfet_03v3 ad=52n pd=1.104m as=52n ps=1.104m w=1000 l=400
X19 VDD.t25 VGP.t0 VGP.t1 VDD.t24 pfet_03v3 ad=52n pd=1.104m as=52n ps=1.104m w=1000 l=400
X20 VDD.t33 VGP.t24 PMID.t11 VDD.t32 pfet_03v3 ad=52n pd=1.104m as=52n ps=1.104m w=1000 l=400
X21 PMID.t12 VGP.t23 VDD.t35 VDD.t34 pfet_03v3 ad=52n pd=1.104m as=52n ps=1.104m w=1000 l=400
X22 VDD.t43 VGP.t18 VGP.t19 VDD.t42 pfet_03v3 ad=52n pd=1.104m as=52n ps=1.104m w=1000 l=400
X23 PMID.t19 UPB.t8 CP_OUT.t11 VDD.t51 pfet_03v3 ad=52n pd=1.104m as=52n ps=1.104m w=1000 l=60
X24 VGP.t7 VGP.t6 VDD.t23 VDD.t22 pfet_03v3 ad=52n pd=1.104m as=52n ps=1.104m w=1000 l=400
X25 PMID.t14 VGP.t21 VDD.t45 VDD.t44 pfet_03v3 ad=52n pd=1.104m as=52n ps=1.104m w=1000 l=400
X26 VGP.t17 VGP.t16 VDD.t13 VDD.t12 pfet_03v3 ad=52n pd=1.104m as=88n ps=2.176m w=1000 l=400
X27 VDD.t21 VGP.t26 PMID.t9 VDD.t20 pfet_03v3 ad=52n pd=1.104m as=52n ps=1.104m w=1000 l=400
X28 PMID.t16 UPB.t4 CP_OUT.t8 VDD.t48 pfet_03v3 ad=52n pd=1.104m as=52n ps=1.104m w=1000 l=60
X29 PMID.t8 VGP.t27 VDD.t19 VDD.t18 pfet_03v3 ad=52n pd=1.104m as=52n ps=1.104m w=1000 l=400
X30 VSS.t9 VGN.t0 VGN.t1 VSS.t8 nfet_03v3 ad=52n pd=1.104m as=52n ps=1.104m w=1000 l=400
X31 VGP.t15 VGP.t14 VDD.t27 VDD.t26 pfet_03v3 ad=52n pd=1.104m as=52n ps=1.104m w=1000 l=400
X32 PMID.t1 UPB.t6 CP_OUT.t3 VDD.t1 pfet_03v3 ad=52n pd=1.104m as=52n ps=1.104m w=1000 l=60
X33 VDD.t11 VGP.t28 PMID.t7 VDD.t10 pfet_03v3 ad=52n pd=1.104m as=52n ps=1.104m w=1000 l=400
X34 CP_OUT.t10 UPB.t9 PMID.t18 VDD.t50 pfet_03v3 ad=52n pd=1.104m as=52n ps=1.104m w=1000 l=60
X35 VDD.t15 VGP.t8 VGP.t9 VDD.t14 pfet_03v3 ad=52n pd=1.104m as=52n ps=1.104m w=1000 l=400
X36 PMID.t3 UPB.t10 CP_OUT.t5 VDD.t3 pfet_03v3 ad=52n pd=1.104m as=52n ps=1.104m w=1000 l=60
X37 VDD.t29 VGP.t4 VGP.t5 VDD.t28 pfet_03v3 ad=52n pd=1.104m as=52n ps=1.104m w=1000 l=400
C0 VDD UP 0.36021f
C1 DOWN NMID 0.32144f
C2 PMID UPB 1.2257f
C3 VGP CP_OUT 0
C4 DOWN CP_OUT 0.1373f
C5 VDD CP_OUT 0.61007f
C6 VGP PMID 2.9199f
C7 VDD PMID 3.79735f
C8 UP CP_OUT 0.00402f
C9 CP_OUT NMID 1.36525f
C10 PMID UP 0.00886f
C11 PMID CP_OUT 4.10912f
C12 VGP UPB 0.00493f
C13 VDD UPB 1.94979f
C14 VGP VDD 16.6035f
C15 UP UPB 0.24901f
C16 VGN NMID 0.37389f
C17 CP_OUT UPB 0.54311f
R0 DOWN.n0 DOWN.t0 77.7629
R1 DOWN.n0 DOWN.t1 63.5105
R2 DOWN DOWN.n0 40.6694
R3 VGN.n3 VGN.n2 56.6383
R4 VGN.n0 VGN.t4 45.7108
R5 VGN.n1 VGN.n0 36.5858
R6 VGN.n2 VGN.n1 36.5858
R7 VGN.n0 VGN.t5 9.1255
R8 VGN.n1 VGN.t0 9.1255
R9 VGN.n2 VGN.t2 9.1255
R10 VGN VGN.n4 6.99311
R11 VGN VGN.n3 1.3055
R12 VGN.n4 VGN.t1 0.3281
R13 VGN.n4 VGN.t3 0.3281
R14 VGN.n3 VGN 0.0647857
R15 UP.n0 UP.t1 52.426
R16 UP.n1 UP.t0 52.381
R17 UP.n2 UP.n0 5.65121
R18 UP.n0 UP 3.84264
R19 UP UP.n2 0.113
R20 UP.n2 UP.n1 0.0455
R21 UP.n1 UP 0.0305
R22 CP_OUT CP_OUT.n8 11.8709
R23 CP_OUT CP_OUT.n10 11.8709
R24 CP_OUT.n2 CP_OUT.n0 6.78025
R25 CP_OUT.n10 CP_OUT.n9 6.36311
R26 CP_OUT.n5 CP_OUT.n4 6.25311
R27 CP_OUT.n7 CP_OUT.n6 6.25311
R28 CP_OUT.n8 CP_OUT.n3 6.25311
R29 CP_OUT.n2 CP_OUT.n1 6.25311
R30 CP_OUT.n8 CP_OUT.n2 0.527643
R31 CP_OUT.n8 CP_OUT.n7 0.527643
R32 CP_OUT.n7 CP_OUT.n5 0.527643
R33 CP_OUT.n4 CP_OUT.t5 0.3645
R34 CP_OUT.n4 CP_OUT.t4 0.3645
R35 CP_OUT.n6 CP_OUT.t11 0.3645
R36 CP_OUT.n6 CP_OUT.t10 0.3645
R37 CP_OUT.n3 CP_OUT.t3 0.3645
R38 CP_OUT.n3 CP_OUT.t9 0.3645
R39 CP_OUT.n1 CP_OUT.t8 0.3645
R40 CP_OUT.n1 CP_OUT.t6 0.3645
R41 CP_OUT.n0 CP_OUT.t0 0.3645
R42 CP_OUT.n0 CP_OUT.t7 0.3645
R43 CP_OUT.n9 CP_OUT.t2 0.3281
R44 CP_OUT.n9 CP_OUT.t1 0.3281
R45 CP_OUT.n10 CP_OUT 0.103357
R46 CP_OUT.n5 CP_OUT 0.0647857
R47 VGP.n19 VGP.n18 58.2026
R48 VGP.n0 VGP.t20 45.7108
R49 VGP.n1 VGP.n0 36.5858
R50 VGP.n2 VGP.n1 36.5858
R51 VGP.n3 VGP.n2 36.5858
R52 VGP.n4 VGP.n3 36.5858
R53 VGP.n5 VGP.n4 36.5858
R54 VGP.n6 VGP.n5 36.5858
R55 VGP.n7 VGP.n6 36.5858
R56 VGP.n8 VGP.n7 36.5858
R57 VGP.n9 VGP.n8 36.5858
R58 VGP.n10 VGP.n9 36.5858
R59 VGP.n11 VGP.n10 36.5858
R60 VGP.n12 VGP.n11 36.5858
R61 VGP.n13 VGP.n12 36.5858
R62 VGP.n14 VGP.n13 36.5858
R63 VGP.n15 VGP.n14 36.5858
R64 VGP.n16 VGP.n15 36.5858
R65 VGP.n17 VGP.n16 36.5858
R66 VGP.n18 VGP.n17 36.5858
R67 VGP.n0 VGP.t21 9.1255
R68 VGP.n1 VGP.t18 9.1255
R69 VGP.n2 VGP.t10 9.1255
R70 VGP.n3 VGP.t2 9.1255
R71 VGP.n4 VGP.t12 9.1255
R72 VGP.n5 VGP.t22 9.1255
R73 VGP.n6 VGP.t23 9.1255
R74 VGP.n7 VGP.t24 9.1255
R75 VGP.n8 VGP.t25 9.1255
R76 VGP.n9 VGP.t4 9.1255
R77 VGP.n10 VGP.t14 9.1255
R78 VGP.n11 VGP.t0 9.1255
R79 VGP.n12 VGP.t6 9.1255
R80 VGP.n13 VGP.t26 9.1255
R81 VGP.n14 VGP.t27 9.1255
R82 VGP.n15 VGP.t28 9.1255
R83 VGP.n16 VGP.t29 9.1255
R84 VGP.n17 VGP.t8 9.1255
R85 VGP.n18 VGP.t16 9.1255
R86 VGP.n22 VGP.n20 7.87311
R87 VGP.n28 VGP.n27 6.25311
R88 VGP.n26 VGP.n25 6.25311
R89 VGP.n24 VGP.n23 6.25311
R90 VGP.n22 VGP.n21 6.25311
R91 VGP.n24 VGP.n22 4.8605
R92 VGP.n28 VGP.n26 4.8605
R93 VGP VGP.n28 2.61371
R94 VGP VGP.n19 1.3055
R95 VGP.n26 VGP 0.976036
R96 VGP VGP.n24 0.644964
R97 VGP.n27 VGP.t9 0.3645
R98 VGP.n27 VGP.t17 0.3645
R99 VGP.n25 VGP.t1 0.3645
R100 VGP.n25 VGP.t7 0.3645
R101 VGP.n23 VGP.t5 0.3645
R102 VGP.n23 VGP.t15 0.3645
R103 VGP.n21 VGP.t3 0.3645
R104 VGP.n21 VGP.t13 0.3645
R105 VGP.n20 VGP.t19 0.3645
R106 VGP.n20 VGP.t11 0.3645
R107 VGP.n19 VGP 0.0647857
R108 VDD.t0 VDD.t4 985.938
R109 VDD.n0 VDD.t2 759.375
R110 VDD.t46 VDD.t44 393.75
R111 VDD.t44 VDD.t42 393.75
R112 VDD.t42 VDD.t40 393.75
R113 VDD.t40 VDD.t38 393.75
R114 VDD.t38 VDD.t36 393.75
R115 VDD.t36 VDD.t8 393.75
R116 VDD.t8 VDD.t34 393.75
R117 VDD.t34 VDD.t32 393.75
R118 VDD.t32 VDD.t30 393.75
R119 VDD.t30 VDD.t28 393.75
R120 VDD.t28 VDD.t26 393.75
R121 VDD.t26 VDD.t24 393.75
R122 VDD.t24 VDD.t22 393.75
R123 VDD.t22 VDD.t20 393.75
R124 VDD.t20 VDD.t18 393.75
R125 VDD.t18 VDD.t10 393.75
R126 VDD.t10 VDD.t16 393.75
R127 VDD.t16 VDD.t14 393.75
R128 VDD.t14 VDD.t12 393.75
R129 VDD.n0 VDD.t46 392.188
R130 VDD.t7 VDD.t0 128.125
R131 VDD.t48 VDD.t7 128.125
R132 VDD.t6 VDD.t48 128.125
R133 VDD.t1 VDD.t6 128.125
R134 VDD.t49 VDD.t1 128.125
R135 VDD.t51 VDD.t49 128.125
R136 VDD.t50 VDD.t51 128.125
R137 VDD.t3 VDD.t50 128.125
R138 VDD.t2 VDD.t3 128.125
R139 VDD VDD.t5 20.5006
R140 VDD VDD.n20 15.955
R141 VDD.n15 VDD.t13 8.23711
R142 VDD.n1 VDD.n0 6.90037
R143 VDD.n1 VDD.t47 6.61711
R144 VDD.n19 VDD.n18 6.25311
R145 VDD.n15 VDD.n14 6.25311
R146 VDD.n17 VDD.n16 6.25311
R147 VDD.n13 VDD.n12 6.25311
R148 VDD.n11 VDD.n10 6.25311
R149 VDD.n9 VDD.n8 6.25311
R150 VDD.n7 VDD.n6 6.25311
R151 VDD.n5 VDD.n4 6.25311
R152 VDD.n3 VDD.n2 6.25311
R153 VDD.n3 VDD.n1 1.6205
R154 VDD.n5 VDD.n3 1.6205
R155 VDD.n7 VDD.n5 1.6205
R156 VDD.n9 VDD.n7 1.6205
R157 VDD.n11 VDD.n9 1.6205
R158 VDD.n13 VDD.n11 1.6205
R159 VDD.n19 VDD.n17 1.60657
R160 VDD.n20 VDD.n13 1.57229
R161 VDD.n17 VDD 0.852286
R162 VDD VDD.n15 0.768714
R163 VDD.n18 VDD.t23 0.3645
R164 VDD.n18 VDD.t21 0.3645
R165 VDD.n14 VDD.t17 0.3645
R166 VDD.n14 VDD.t15 0.3645
R167 VDD.n16 VDD.t19 0.3645
R168 VDD.n16 VDD.t11 0.3645
R169 VDD.n12 VDD.t27 0.3645
R170 VDD.n12 VDD.t25 0.3645
R171 VDD.n10 VDD.t31 0.3645
R172 VDD.n10 VDD.t29 0.3645
R173 VDD.n8 VDD.t35 0.3645
R174 VDD.n8 VDD.t33 0.3645
R175 VDD.n6 VDD.t37 0.3645
R176 VDD.n6 VDD.t9 0.3645
R177 VDD.n4 VDD.t41 0.3645
R178 VDD.n4 VDD.t39 0.3645
R179 VDD.n2 VDD.t45 0.3645
R180 VDD.n2 VDD.t43 0.3645
R181 VDD.n20 VDD.n19 0.0176429
R182 VSS.t0 VSS.n3 4616.61
R183 VSS.n4 VSS.t2 820.293
R184 VSS.n4 VSS.t1 753.029
R185 VSS.n3 VSS.t4 438.036
R186 VSS.t4 VSS.t10 413.428
R187 VSS.t10 VSS.t8 413.428
R188 VSS.t8 VSS.t6 413.428
R189 VSS.t1 VSS.t0 134.529
R190 VSS VSS.t3 23.0786
R191 VSS VSS.n4 19.8931
R192 VSS.n0 VSS 14.186
R193 VSS.n0 VSS.t7 7.48464
R194 VSS.n3 VSS.n2 6.84635
R195 VSS.n2 VSS.t5 6.69071
R196 VSS VSS.n1 6.36311
R197 VSS.n2 VSS 1.6205
R198 VSS VSS.n0 0.781571
R199 VSS.n1 VSS.t11 0.3281
R200 VSS.n1 VSS.t9 0.3281
R201 NMID.t1 NMID.n0 7.21785
R202 NMID NMID.n0 0.0551429
R203 NMID NMID.n0 10.328
R204 NMID NMID.n1 15.5574
R205 NMID.t2 NMID.n1 0.3281
R206 NMID.n1 NMID.t3 0.3281
R207 NMID.n0 NMID.t0 6.69071
R208 PMID.n0 PMID.t14 0.3645
R209 PMID.n0 PMID.t15 0.3645
R210 PMID.n15 PMID.n0 10.9024
R211 PMID.n15 PMID 5.87086
R212 PMID.n13 PMID.n15 4.7705
R213 PMID.n13 PMID.n14 10.9474
R214 PMID.n14 PMID.t12 0.3645
R215 PMID.n14 PMID.t13 0.3645
R216 PMID PMID.n13 1.4855
R217 PMID PMID.n11 4.7255
R218 PMID.n11 PMID.n12 10.9474
R219 PMID.n12 PMID.t8 0.3645
R220 PMID.n12 PMID.t9 0.3645
R221 PMID.n11 PMID.n10 12.4324
R222 PMID.n10 PMID.t6 0.3645
R223 PMID.n10 PMID.t7 0.3645
R224 PMID PMID.n9 10.9474
R225 PMID.n9 PMID.t10 0.3645
R226 PMID.n9 PMID.t11 0.3645
R227 PMID.n1 PMID 10.5305
R228 PMID PMID.n1 0.318714
R229 PMID.n1 PMID.n4 0.527643
R230 PMID.n4 PMID.n6 0.527643
R231 PMID.n6 PMID.n8 0.527643
R232 PMID.t0 PMID.n8 7.14425
R233 PMID.n7 PMID.n8 6.25311
R234 PMID.t16 PMID.n7 0.3645
R235 PMID.n7 PMID.t5 0.3645
R236 PMID.n5 PMID.n6 6.25311
R237 PMID.t1 PMID.n5 0.3645
R238 PMID.n5 PMID.t4 0.3645
R239 PMID.n3 PMID.n4 6.25311
R240 PMID.t19 PMID.n3 0.3645
R241 PMID.n3 PMID.t17 0.3645
R242 PMID.n2 PMID.n1 6.25311
R243 PMID.t3 PMID.n2 0.3645
R244 PMID.n2 PMID.t18 0.3645
R245 PMID PMID.t2 6.82604
R246 UPB.t1 UPB 22.0567
R247 UPB UPB.n0 2.09943
R248 UPB UPB.n0 2.58479
R249 UPB UPB.n1 37.201
R250 UPB.n1 UPB.n2 14.2529
R251 UPB.n2 UPB.n3 14.2529
R252 UPB.n3 UPB.n4 14.2529
R253 UPB.n4 UPB.n5 14.2529
R254 UPB.n5 UPB.n6 14.2529
R255 UPB.n6 UPB.n7 14.2529
R256 UPB.n7 UPB.n8 14.2529
R257 UPB.n8 UPB.n9 14.2529
R258 UPB.t2 UPB.n9 77.7629
R259 UPB.t3 UPB.n9 63.5105
R260 UPB.t4 UPB.n8 63.5105
R261 UPB.t5 UPB.n7 63.5105
R262 UPB.t6 UPB.n6 63.5105
R263 UPB.t7 UPB.n5 63.5105
R264 UPB.t8 UPB.n4 63.5105
R265 UPB.t9 UPB.n3 63.5105
R266 UPB.t10 UPB.n2 63.5105
R267 UPB.t11 UPB.n1 63.5105
R268 UPB.n0 UPB.t0 15.8369
C18 DOWN VSS 1.121f
C19 VGN VSS 5.53399f
C20 UP VSS 1.16904f
C21 CP_OUT VSS 2.68516f
C22 VGP VSS 8.20895f
C23 VDD VSS 57.67982f
C24 NMID VSS 4.31202f $ **FLOATING
C25 PMID VSS 5.37271f $ **FLOATING
C26 UPB VSS 4.34044f $ **FLOATING
C27 UPB.t1 VSS 0.12752f $ **FLOATING
C28 UPB.t0 VSS 0.12136f $ **FLOATING
C29 UPB.n0 VSS 0.2866f $ **FLOATING
C30 UPB.t11 VSS 0.1286f $ **FLOATING
C31 UPB.n1 VSS 0.13857f $ **FLOATING
C32 UPB.t10 VSS 0.1286f $ **FLOATING
C33 UPB.n2 VSS 0.08799f $ **FLOATING
C34 UPB.t9 VSS 0.1286f $ **FLOATING
C35 UPB.n3 VSS 0.08799f $ **FLOATING
C36 UPB.t8 VSS 0.1286f $ **FLOATING
C37 UPB.n4 VSS 0.08799f $ **FLOATING
C38 UPB.t7 VSS 0.1286f $ **FLOATING
C39 UPB.n5 VSS 0.08799f $ **FLOATING
C40 UPB.t6 VSS 0.1286f $ **FLOATING
C41 UPB.n6 VSS 0.08799f $ **FLOATING
C42 UPB.t5 VSS 0.1286f $ **FLOATING
C43 UPB.n7 VSS 0.08799f $ **FLOATING
C44 UPB.t4 VSS 0.1286f $ **FLOATING
C45 UPB.n8 VSS 0.08799f $ **FLOATING
C46 UPB.t3 VSS 0.1286f $ **FLOATING
C47 UPB.n9 VSS 0.15985f $ **FLOATING
C48 UPB.t2 VSS 0.14472f $ **FLOATING
C49 PMID.t15 VSS 0.11284f $ **FLOATING
C50 PMID.n0 VSS 0.44668f $ **FLOATING
C51 PMID.n1 VSS 0.14886f $ **FLOATING
C52 PMID.t2 VSS 0.59593f $ **FLOATING
C53 PMID.t3 VSS 0.11284f $ **FLOATING
C54 PMID.t18 VSS 0.11284f $ **FLOATING
C55 PMID.n2 VSS 0.46456f $ **FLOATING
C56 PMID.t19 VSS 0.11284f $ **FLOATING
C57 PMID.t17 VSS 0.11284f $ **FLOATING
C58 PMID.n3 VSS 0.46456f $ **FLOATING
C59 PMID.n4 VSS 0.12687f $ **FLOATING
C60 PMID.t1 VSS 0.11284f $ **FLOATING
C61 PMID.t4 VSS 0.11284f $ **FLOATING
C62 PMID.n5 VSS 0.46456f $ **FLOATING
C63 PMID.n6 VSS 0.12687f $ **FLOATING
C64 PMID.t16 VSS 0.11284f $ **FLOATING
C65 PMID.t5 VSS 0.11284f $ **FLOATING
C66 PMID.n7 VSS 0.46456f $ **FLOATING
C67 PMID.n8 VSS 0.24234f $ **FLOATING
C68 PMID.t0 VSS 0.60205f $ **FLOATING
C69 PMID.t10 VSS 0.11284f $ **FLOATING
C70 PMID.t11 VSS 0.11284f $ **FLOATING
C71 PMID.n9 VSS 0.44754f $ **FLOATING
C72 PMID.t6 VSS 0.11284f $ **FLOATING
C73 PMID.t7 VSS 0.11284f $ **FLOATING
C74 PMID.n10 VSS 0.48841f $ **FLOATING
C75 PMID.n11 VSS 1.0007f $ **FLOATING
C76 PMID.t8 VSS 0.11284f $ **FLOATING
C77 PMID.t9 VSS 0.11284f $ **FLOATING
C78 PMID.n12 VSS 0.44754f $ **FLOATING
C79 PMID.n13 VSS 0.70286f $ **FLOATING
C80 PMID.t12 VSS 0.11284f $ **FLOATING
C81 PMID.t13 VSS 0.11284f $ **FLOATING
C82 PMID.n14 VSS 0.44754f $ **FLOATING
C83 PMID.n15 VSS 0.62701f $ **FLOATING
C84 PMID.t14 VSS 0.11284f $ **FLOATING
C85 NMID.t1 VSS 0.28433f $ **FLOATING
C86 NMID.t0 VSS 0.27999f $ **FLOATING
C87 NMID.n0 VSS 0.12748f $ **FLOATING
C88 NMID.t2 VSS 0.05337f $ **FLOATING
C89 NMID.t3 VSS 0.05337f $ **FLOATING
C90 NMID.n1 VSS 0.24237f $ **FLOATING
C91 VDD.t5 VSS 0.04651f $ **FLOATING
C92 VDD.t4 VSS 1.17663f $ **FLOATING
C93 VDD.t0 VSS 0.95225f $ **FLOATING
C94 VDD.t7 VSS 0.21903f $ **FLOATING
C95 VDD.t48 VSS 0.21903f $ **FLOATING
C96 VDD.t6 VSS 0.21903f $ **FLOATING
C97 VDD.t1 VSS 0.21903f $ **FLOATING
C98 VDD.t49 VSS 0.21903f $ **FLOATING
C99 VDD.t51 VSS 0.21903f $ **FLOATING
C100 VDD.t50 VSS 0.21903f $ **FLOATING
C101 VDD.t3 VSS 0.21903f $ **FLOATING
C102 VDD.t2 VSS 0.7586f $ **FLOATING
C103 VDD.t12 VSS 1.2207f $ **FLOATING
C104 VDD.t14 VSS 0.67312f $ **FLOATING
C105 VDD.t16 VSS 0.67312f $ **FLOATING
C106 VDD.t10 VSS 0.67312f $ **FLOATING
C107 VDD.t18 VSS 0.67312f $ **FLOATING
C108 VDD.t20 VSS 0.67312f $ **FLOATING
C109 VDD.t22 VSS 0.67312f $ **FLOATING
C110 VDD.t24 VSS 0.67312f $ **FLOATING
C111 VDD.t26 VSS 0.67312f $ **FLOATING
C112 VDD.t28 VSS 0.67312f $ **FLOATING
C113 VDD.t30 VSS 0.67312f $ **FLOATING
C114 VDD.t32 VSS 0.67312f $ **FLOATING
C115 VDD.t34 VSS 0.67312f $ **FLOATING
C116 VDD.t8 VSS 0.67312f $ **FLOATING
C117 VDD.t36 VSS 0.67312f $ **FLOATING
C118 VDD.t38 VSS 0.67312f $ **FLOATING
C119 VDD.t40 VSS 0.67312f $ **FLOATING
C120 VDD.t42 VSS 0.67312f $ **FLOATING
C121 VDD.t44 VSS 0.67312f $ **FLOATING
C122 VDD.t46 VSS 0.67179f $ **FLOATING
C123 VDD.n0 VSS 0.9907f $ **FLOATING
C124 VDD.t47 VSS 0.14253f $ **FLOATING
C125 VDD.n1 VSS 0.07838f $ **FLOATING
C126 VDD.t45 VSS 0.02713f $ **FLOATING
C127 VDD.t43 VSS 0.02713f $ **FLOATING
C128 VDD.n2 VSS 0.11169f $ **FLOATING
C129 VDD.n3 VSS 0.07023f $ **FLOATING
C130 VDD.t41 VSS 0.02713f $ **FLOATING
C131 VDD.t39 VSS 0.02713f $ **FLOATING
C132 VDD.n4 VSS 0.11169f $ **FLOATING
C133 VDD.n5 VSS 0.07023f $ **FLOATING
C134 VDD.t37 VSS 0.02713f $ **FLOATING
C135 VDD.t9 VSS 0.02713f $ **FLOATING
C136 VDD.n6 VSS 0.11169f $ **FLOATING
C137 VDD.n7 VSS 0.07023f $ **FLOATING
C138 VDD.t35 VSS 0.02713f $ **FLOATING
C139 VDD.t33 VSS 0.02713f $ **FLOATING
C140 VDD.n8 VSS 0.11169f $ **FLOATING
C141 VDD.n9 VSS 0.07023f $ **FLOATING
C142 VDD.t31 VSS 0.02713f $ **FLOATING
C143 VDD.t29 VSS 0.02713f $ **FLOATING
C144 VDD.n10 VSS 0.11169f $ **FLOATING
C145 VDD.n11 VSS 0.07023f $ **FLOATING
C146 VDD.t27 VSS 0.02713f $ **FLOATING
C147 VDD.t25 VSS 0.02713f $ **FLOATING
C148 VDD.n12 VSS 0.11169f $ **FLOATING
C149 VDD.n13 VSS 0.06939f $ **FLOATING
C150 VDD.t13 VSS 0.15234f $ **FLOATING
C151 VDD.t17 VSS 0.02713f $ **FLOATING
C152 VDD.t15 VSS 0.02713f $ **FLOATING
C153 VDD.n14 VSS 0.11169f $ **FLOATING
C154 VDD.n15 VSS 0.09479f $ **FLOATING
C155 VDD.t19 VSS 0.02713f $ **FLOATING
C156 VDD.t11 VSS 0.02713f $ **FLOATING
C157 VDD.n16 VSS 0.11169f $ **FLOATING
C158 VDD.n17 VSS 0.05603f $ **FLOATING
C159 VDD.t23 VSS 0.02713f $ **FLOATING
C160 VDD.t21 VSS 0.02713f $ **FLOATING
C161 VDD.n18 VSS 0.11169f $ **FLOATING
C162 VDD.n19 VSS 0.04249f $ **FLOATING
C163 VDD.n20 VSS 0.07855f $ **FLOATING
C164 VGP.t16 VSS 0.51277f $ **FLOATING
C165 VGP.t8 VSS 0.51277f $ **FLOATING
C166 VGP.t29 VSS 0.51277f $ **FLOATING
C167 VGP.t28 VSS 0.51277f $ **FLOATING
C168 VGP.t27 VSS 0.51277f $ **FLOATING
C169 VGP.t26 VSS 0.51277f $ **FLOATING
C170 VGP.t6 VSS 0.51277f $ **FLOATING
C171 VGP.t0 VSS 0.51277f $ **FLOATING
C172 VGP.t14 VSS 0.51277f $ **FLOATING
C173 VGP.t4 VSS 0.51277f $ **FLOATING
C174 VGP.t25 VSS 0.51277f $ **FLOATING
C175 VGP.t24 VSS 0.51277f $ **FLOATING
C176 VGP.t23 VSS 0.51277f $ **FLOATING
C177 VGP.t22 VSS 0.51277f $ **FLOATING
C178 VGP.t12 VSS 0.51277f $ **FLOATING
C179 VGP.t2 VSS 0.51277f $ **FLOATING
C180 VGP.t10 VSS 0.51277f $ **FLOATING
C181 VGP.t18 VSS 0.51277f $ **FLOATING
C182 VGP.t21 VSS 0.51277f $ **FLOATING
C183 VGP.t20 VSS 0.71971f $ **FLOATING
C184 VGP.n0 VSS 0.32604f $ **FLOATING
C185 VGP.n1 VSS 0.27442f $ **FLOATING
C186 VGP.n2 VSS 0.27442f $ **FLOATING
C187 VGP.n3 VSS 0.27442f $ **FLOATING
C188 VGP.n4 VSS 0.27442f $ **FLOATING
C189 VGP.n5 VSS 0.27442f $ **FLOATING
C190 VGP.n6 VSS 0.27442f $ **FLOATING
C191 VGP.n7 VSS 0.27442f $ **FLOATING
C192 VGP.n8 VSS 0.27442f $ **FLOATING
C193 VGP.n9 VSS 0.27442f $ **FLOATING
C194 VGP.n10 VSS 0.27442f $ **FLOATING
C195 VGP.n11 VSS 0.27442f $ **FLOATING
C196 VGP.n12 VSS 0.27442f $ **FLOATING
C197 VGP.n13 VSS 0.27442f $ **FLOATING
C198 VGP.n14 VSS 0.27442f $ **FLOATING
C199 VGP.n15 VSS 0.27442f $ **FLOATING
C200 VGP.n16 VSS 0.27442f $ **FLOATING
C201 VGP.n17 VSS 0.27442f $ **FLOATING
C202 VGP.n18 VSS 0.29602f $ **FLOATING
C203 VGP.n19 VSS 1.20065f $ **FLOATING
C204 VGP.t19 VSS 0.04721f $ **FLOATING
C205 VGP.t11 VSS 0.04721f $ **FLOATING
C206 VGP.n20 VSS 0.20981f $ **FLOATING
C207 VGP.t3 VSS 0.04721f $ **FLOATING
C208 VGP.t13 VSS 0.04721f $ **FLOATING
C209 VGP.n21 VSS 0.19436f $ **FLOATING
C210 VGP.n22 VSS 0.28432f $ **FLOATING
C211 VGP.t5 VSS 0.04721f $ **FLOATING
C212 VGP.t15 VSS 0.04721f $ **FLOATING
C213 VGP.n23 VSS 0.19436f $ **FLOATING
C214 VGP.n24 VSS 0.19386f $ **FLOATING
C215 VGP.t1 VSS 0.04721f $ **FLOATING
C216 VGP.t7 VSS 0.04721f $ **FLOATING
C217 VGP.n25 VSS 0.19436f $ **FLOATING
C218 VGP.n26 VSS 0.20433f $ **FLOATING
C219 VGP.t9 VSS 0.04721f $ **FLOATING
C220 VGP.t17 VSS 0.04721f $ **FLOATING
C221 VGP.n27 VSS 0.19436f $ **FLOATING
C222 VGP.n28 VSS 0.25756f $ **FLOATING
C223 CP_OUT.t0 VSS 0.13195f $ **FLOATING
C224 CP_OUT.t7 VSS 0.13195f $ **FLOATING
C225 CP_OUT.n0 VSS 0.55206f $ **FLOATING
C226 CP_OUT.t8 VSS 0.13195f $ **FLOATING
C227 CP_OUT.t6 VSS 0.13195f $ **FLOATING
C228 CP_OUT.n1 VSS 0.54327f $ **FLOATING
C229 CP_OUT.n2 VSS 0.25268f $ **FLOATING
C230 CP_OUT.t3 VSS 0.13195f $ **FLOATING
C231 CP_OUT.t9 VSS 0.13195f $ **FLOATING
C232 CP_OUT.n3 VSS 0.54327f $ **FLOATING
C233 CP_OUT.t5 VSS 0.13195f $ **FLOATING
C234 CP_OUT.t4 VSS 0.13195f $ **FLOATING
C235 CP_OUT.n4 VSS 0.54327f $ **FLOATING
C236 CP_OUT.n5 VSS 0.10743f $ **FLOATING
C237 CP_OUT.t11 VSS 0.13195f $ **FLOATING
C238 CP_OUT.t10 VSS 0.13195f $ **FLOATING
C239 CP_OUT.n6 VSS 0.54327f $ **FLOATING
C240 CP_OUT.n7 VSS 0.14836f $ **FLOATING
C241 CP_OUT.n8 VSS 0.23868f $ **FLOATING
C242 CP_OUT.t2 VSS 0.13195f $ **FLOATING
C243 CP_OUT.t1 VSS 0.13195f $ **FLOATING
C244 CP_OUT.n9 VSS 0.53844f $ **FLOATING
C245 CP_OUT.n10 VSS 0.18781f $ **FLOATING
C246 UP.t1 VSS 0.05092f $ **FLOATING
C247 UP.n0 VSS 0.58372f $ **FLOATING
C248 UP.t0 VSS 0.03823f $ **FLOATING
C249 UP.n1 VSS 0.05044f $ **FLOATING
C250 UP.n2 VSS 0.21523f $ **FLOATING
C251 VGN.t2 VSS 0.0473f $ **FLOATING
C252 VGN.t0 VSS 0.0473f $ **FLOATING
C253 VGN.t5 VSS 0.0473f $ **FLOATING
C254 VGN.t4 VSS 0.0664f $ **FLOATING
C255 VGN.n0 VSS 0.03008f $ **FLOATING
C256 VGN.n1 VSS 0.02532f $ **FLOATING
C257 VGN.n2 VSS 0.02719f $ **FLOATING
C258 VGN.n3 VSS 0.03482f $ **FLOATING
C259 VGN.t1 VSS 0.00436f $ **FLOATING
C260 VGN.t3 VSS 0.00436f $ **FLOATING
C261 VGN.n4 VSS 0.01815f $ **FLOATING
C262 DOWN.t1 VSS 0.08224f $ **FLOATING
C263 DOWN.t0 VSS 0.09255f $ **FLOATING
C264 DOWN.n0 VSS 0.13333f $ **FLOATING
