* NGSPICE file created from vco_core_flat.ext - technology: gf180mcuD

.option scale=5n

X0 OUT_n.t1 OUT_p.t24 ISS.t2 GND.t10 nfet_03v3 ad=41.6n pd=0.904m as=70.4n ps=1.776m w=800 l=56
X1 ISS.t5 OUT_p.t17 OUT_n.t8 GND.t17 nfet_03v3 ad=41.6n pd=0.904m as=41.6n ps=0.904m w=800 l=56
X2 OUT_p.t2 OUT_n.t29 VDD.t1 VDD.t0 pfet_03v3 ad=0.1456u pd=2.904m as=0.2464u ps=5.776m w=2800 l=56
X3 OUT_n.t7 OUT_p.t18 ISS.t16 GND.t16 nfet_03v3 ad=41.6n pd=0.904m as=41.6n ps=0.904m w=800 l=56
X4 OUT_p.t5 OUT_n.t25 VDD.t9 VDD.t8 pfet_03v3 ad=0.2464u pd=5.776m as=0.1456u ps=2.904m w=2800 l=56
X5 OUT_p.t4 OUT_n.t27 VDD.t5 VDD.t4 pfet_03v3 ad=0.1456u pd=2.904m as=0.1456u ps=2.904m w=2800 l=56
X6 VDD.t7 OUT_n.t26 OUT_p.t7 VDD.t6 pfet_03v3 ad=0.1456u pd=2.904m as=0.1456u ps=2.904m w=2800 l=56
X7 OUT_p.t12 OUT_n.t24 ISS.t17 GND.t0 nfet_03v3 ad=41.6n pd=0.904m as=70.4n ps=1.776m w=800 l=56
X8 OUT_n.t5 OUT_p.t20 ISS.t6 GND.t14 nfet_03v3 ad=41.6n pd=0.904m as=41.6n ps=0.904m w=800 l=56
X9 ISS.t13 OUT_n.t15 OUT_p.t10 GND.t9 nfet_03v3 ad=70.4n pd=1.776m as=41.6n ps=0.904m w=800 l=56
X10 VDD.t3 OUT_n.t28 OUT_p.t1 VDD.t2 pfet_03v3 ad=0.1456u pd=2.904m as=0.1456u ps=2.904m w=2800 l=56
X11 ISS.t4 OUT_p.t21 OUT_n.t4 GND.t13 nfet_03v3 ad=41.6n pd=0.904m as=41.6n ps=0.904m w=800 l=56
X12 ISS.t8 OUT_p.t19 OUT_n.t6 GND.t15 nfet_03v3 ad=41.6n pd=0.904m as=41.6n ps=0.904m w=800 l=56
X13 OUT_p.t14 OUT_n.t16 ISS.t19 GND.t8 nfet_03v3 ad=41.6n pd=0.904m as=41.6n ps=0.904m w=800 l=56
X14 OUT_n.t0 OUT_p.t27 VDD.t15 VDD.t14 pfet_03v3 ad=0.1456u pd=2.904m as=0.1456u ps=2.904m w=2800 l=56
X15 ISS.t11 OUT_n.t23 OUT_p.t8 GND.t1 nfet_03v3 ad=41.6n pd=0.904m as=41.6n ps=0.904m w=800 l=56
X16 OUT_n.t11 OUT_p.t25 VDD.t19 VDD.t18 pfet_03v3 ad=0.2464u pd=5.776m as=0.1456u ps=2.904m w=2800 l=56
X17 OUT_p.t11 OUT_n.t22 ISS.t14 GND.t2 nfet_03v3 ad=41.6n pd=0.904m as=41.6n ps=0.904m w=800 l=56
X18 VDD.t13 OUT_p.t28 OUT_n.t14 VDD.t12 pfet_03v3 ad=0.1456u pd=2.904m as=0.1456u ps=2.904m w=2800 l=56
X19 VDD.t17 OUT_p.t26 OUT_n.t12 VDD.t16 pfet_03v3 ad=0.1456u pd=2.904m as=0.1456u ps=2.904m w=2800 l=56
X20 OUT_n.t3 OUT_p.t22 ISS.t15 GND.t12 nfet_03v3 ad=41.6n pd=0.904m as=41.6n ps=0.904m w=800 l=56
X21 ISS.t18 OUT_n.t19 OUT_p.t13 GND.t5 nfet_03v3 ad=41.6n pd=0.904m as=41.6n ps=0.904m w=800 l=56
X22 ISS.t10 OUT_n.t17 OUT_p.t6 GND.t7 nfet_03v3 ad=41.6n pd=0.904m as=41.6n ps=0.904m w=800 l=56
X23 ISS.t1 OUT_p.t23 OUT_n.t2 GND.t11 nfet_03v3 ad=41.6n pd=0.904m as=41.6n ps=0.904m w=800 l=56
X24 OUT_p.t9 OUT_n.t18 ISS.t12 GND.t6 nfet_03v3 ad=41.6n pd=0.904m as=41.6n ps=0.904m w=800 l=56
X25 ISS.t9 OUT_p.t15 OUT_n.t10 GND.t19 nfet_03v3 ad=70.4n pd=1.776m as=41.6n ps=0.904m w=800 l=56
X26 OUT_n.t9 OUT_p.t16 ISS.t7 GND.t18 nfet_03v3 ad=41.6n pd=0.904m as=41.6n ps=0.904m w=800 l=56
X27 ISS.t0 OUT_n.t21 OUT_p.t0 GND.t3 nfet_03v3 ad=41.6n pd=0.904m as=41.6n ps=0.904m w=800 l=56
X28 OUT_n.t13 OUT_p.t29 VDD.t11 VDD.t10 pfet_03v3 ad=0.1456u pd=2.904m as=0.2464u ps=5.776m w=2800 l=56
X29 OUT_p.t3 OUT_n.t20 ISS.t3 GND.t4 nfet_03v3 ad=41.6n pd=0.904m as=41.6n ps=0.904m w=800 l=56
C0 OUT_n ISS 3.91315f
C1 OUT_p OUT_n 4.02031f
C2 OUT_p ISS 3.92534f
C3 OUT_n VDD 9.06446f
C4 ISS VDD 0
C5 OUT_p VDD 9.18212f
R0 ISS.n11 ISS.t17 7.21579
R1 ISS.n1 ISS.t9 7.21579
R2 ISS.n9 ISS.t13 6.7015
R3 ISS.n8 ISS.t2 6.7015
R4 ISS.n11 ISS.n10 6.292
R5 ISS.n13 ISS.n12 6.292
R6 ISS.n15 ISS.n14 6.292
R7 ISS.n17 ISS.n16 6.292
R8 ISS.n7 ISS.n6 6.292
R9 ISS.n5 ISS.n4 6.292
R10 ISS.n3 ISS.n2 6.292
R11 ISS.n1 ISS.n0 6.292
R12 ISS.n9 ISS.n8 2.2505
R13 ISS.n3 ISS.n1 0.514786
R14 ISS.n5 ISS.n3 0.514786
R15 ISS.n7 ISS.n5 0.514786
R16 ISS.n8 ISS.n7 0.514786
R17 ISS.n17 ISS.n15 0.514786
R18 ISS.n15 ISS.n13 0.514786
R19 ISS.n13 ISS.n11 0.514786
R20 ISS.n10 ISS.t14 0.41
R21 ISS.n10 ISS.t11 0.41
R22 ISS.n12 ISS.t3 0.41
R23 ISS.n12 ISS.t0 0.41
R24 ISS.n14 ISS.t12 0.41
R25 ISS.n14 ISS.t18 0.41
R26 ISS.n16 ISS.t19 0.41
R27 ISS.n16 ISS.t10 0.41
R28 ISS.n6 ISS.t15 0.41
R29 ISS.n6 ISS.t1 0.41
R30 ISS.n4 ISS.t6 0.41
R31 ISS.n4 ISS.t4 0.41
R32 ISS.n2 ISS.t16 0.41
R33 ISS.n2 ISS.t8 0.41
R34 ISS.n0 ISS.t7 0.41
R35 ISS.n0 ISS.t5 0.41
R36 ISS ISS.n17 0.321929
R37 ISS ISS.n9 0.193357
R38 OUT_p.n13 OUT_p.t25 208.757
R39 OUT_p.n13 OUT_p.t26 182.5
R40 OUT_p.n14 OUT_p.t27 182.5
R41 OUT_p.n15 OUT_p.t28 182.5
R42 OUT_p.n16 OUT_p.t29 182.5
R43 OUT_p.n17 OUT_p.t15 92.6015
R44 OUT_p.n17 OUT_p.t16 75.3469
R45 OUT_p.n18 OUT_p.t17 75.3469
R46 OUT_p.n19 OUT_p.t18 75.3469
R47 OUT_p.n20 OUT_p.t19 75.3469
R48 OUT_p.n21 OUT_p.t20 75.3469
R49 OUT_p.n22 OUT_p.t21 75.3469
R50 OUT_p.n23 OUT_p.t22 75.3469
R51 OUT_p.n24 OUT_p.t23 75.3469
R52 OUT_p.n25 OUT_p.t24 75.3469
R53 OUT_p.n26 OUT_p.n16 57.4995
R54 OUT_p.n26 OUT_p.n25 50.2257
R55 OUT_p.n14 OUT_p.n13 23.2668
R56 OUT_p.n15 OUT_p.n14 23.2668
R57 OUT_p.n16 OUT_p.n15 23.2668
R58 OUT_p.n18 OUT_p.n17 17.255
R59 OUT_p.n19 OUT_p.n18 17.255
R60 OUT_p.n20 OUT_p.n19 17.255
R61 OUT_p.n21 OUT_p.n20 17.255
R62 OUT_p.n22 OUT_p.n21 17.255
R63 OUT_p.n23 OUT_p.n22 17.255
R64 OUT_p.n24 OUT_p.n23 17.255
R65 OUT_p.n25 OUT_p.n24 17.255
R66 OUT_p OUT_p.n3 8.77443
R67 OUT_p.n1 OUT_p.t5 7.78437
R68 OUT_p.n3 OUT_p.n2 7.14008
R69 OUT_p.n1 OUT_p.n0 7.14008
R70 OUT_p.n6 OUT_p.n4 6.80629
R71 OUT_p.n27 OUT_p.n12 6.61871
R72 OUT_p.n12 OUT_p.n11 6.292
R73 OUT_p.n10 OUT_p.n9 6.292
R74 OUT_p.n8 OUT_p.n7 6.292
R75 OUT_p.n6 OUT_p.n5 6.292
R76 OUT_p.n27 OUT_p.n26 4.28621
R77 OUT_p OUT_p.n27 0.844786
R78 OUT_p.n3 OUT_p.n1 0.514786
R79 OUT_p.n8 OUT_p.n6 0.514786
R80 OUT_p.n10 OUT_p.n8 0.514786
R81 OUT_p.n12 OUT_p.n10 0.514786
R82 OUT_p.n11 OUT_p.t8 0.41
R83 OUT_p.n11 OUT_p.t12 0.41
R84 OUT_p.n9 OUT_p.t0 0.41
R85 OUT_p.n9 OUT_p.t11 0.41
R86 OUT_p.n7 OUT_p.t13 0.41
R87 OUT_p.n7 OUT_p.t3 0.41
R88 OUT_p.n5 OUT_p.t6 0.41
R89 OUT_p.n5 OUT_p.t9 0.41
R90 OUT_p.n4 OUT_p.t10 0.41
R91 OUT_p.n4 OUT_p.t14 0.41
R92 OUT_p.n2 OUT_p.t1 0.1305
R93 OUT_p.n2 OUT_p.t2 0.1305
R94 OUT_p.n0 OUT_p.t7 0.1305
R95 OUT_p.n0 OUT_p.t4 0.1305
R96 OUT_n.n13 OUT_n.t25 208.757
R97 OUT_n.n13 OUT_n.t26 182.5
R98 OUT_n.n14 OUT_n.t27 182.5
R99 OUT_n.n15 OUT_n.t28 182.5
R100 OUT_n.n16 OUT_n.t29 182.5
R101 OUT_n.n17 OUT_n.t15 92.6015
R102 OUT_n.n17 OUT_n.t16 75.3469
R103 OUT_n.n18 OUT_n.t17 75.3469
R104 OUT_n.n19 OUT_n.t18 75.3469
R105 OUT_n.n20 OUT_n.t19 75.3469
R106 OUT_n.n21 OUT_n.t20 75.3469
R107 OUT_n.n22 OUT_n.t21 75.3469
R108 OUT_n.n23 OUT_n.t22 75.3469
R109 OUT_n.n24 OUT_n.t23 75.3469
R110 OUT_n.n25 OUT_n.t24 75.3469
R111 OUT_n.n26 OUT_n.n16 61.678
R112 OUT_n.n26 OUT_n.n25 55.0471
R113 OUT_n.n14 OUT_n.n13 23.2668
R114 OUT_n.n15 OUT_n.n14 23.2668
R115 OUT_n.n16 OUT_n.n15 23.2668
R116 OUT_n.n18 OUT_n.n17 17.255
R117 OUT_n.n19 OUT_n.n18 17.255
R118 OUT_n.n20 OUT_n.n19 17.255
R119 OUT_n.n21 OUT_n.n20 17.255
R120 OUT_n.n22 OUT_n.n21 17.255
R121 OUT_n.n23 OUT_n.n22 17.255
R122 OUT_n.n24 OUT_n.n23 17.255
R123 OUT_n.n25 OUT_n.n24 17.255
R124 OUT_n OUT_n.n3 13.0173
R125 OUT_n.n27 OUT_n.n12 11.4401
R126 OUT_n.n2 OUT_n.n0 7.65437
R127 OUT_n.n3 OUT_n.t11 7.27008
R128 OUT_n.n2 OUT_n.n1 7.14008
R129 OUT_n.n6 OUT_n.n4 6.80629
R130 OUT_n.n6 OUT_n.n5 6.292
R131 OUT_n.n8 OUT_n.n7 6.292
R132 OUT_n.n10 OUT_n.n9 6.292
R133 OUT_n.n12 OUT_n.n11 6.292
R134 OUT_n.n27 OUT_n.n26 4.92907
R135 OUT_n OUT_n.n27 0.523357
R136 OUT_n.n3 OUT_n.n2 0.514786
R137 OUT_n.n12 OUT_n.n10 0.514786
R138 OUT_n.n10 OUT_n.n8 0.514786
R139 OUT_n.n8 OUT_n.n6 0.514786
R140 OUT_n.n4 OUT_n.t2 0.41
R141 OUT_n.n4 OUT_n.t1 0.41
R142 OUT_n.n5 OUT_n.t4 0.41
R143 OUT_n.n5 OUT_n.t3 0.41
R144 OUT_n.n7 OUT_n.t6 0.41
R145 OUT_n.n7 OUT_n.t5 0.41
R146 OUT_n.n9 OUT_n.t8 0.41
R147 OUT_n.n9 OUT_n.t7 0.41
R148 OUT_n.n11 OUT_n.t10 0.41
R149 OUT_n.n11 OUT_n.t9 0.41
R150 OUT_n.n0 OUT_n.t14 0.1305
R151 OUT_n.n0 OUT_n.t13 0.1305
R152 OUT_n.n1 OUT_n.t12 0.1305
R153 OUT_n.n1 OUT_n.t0 0.1305
R154 VDD.t6 VDD.t8 47.4782
R155 VDD.t4 VDD.t6 47.4782
R156 VDD.t2 VDD.t4 47.4782
R157 VDD.t0 VDD.t2 47.4782
R158 VDD.t16 VDD.t18 47.4782
R159 VDD.t14 VDD.t16 47.4782
R160 VDD.t12 VDD.t14 47.4782
R161 VDD.t10 VDD.t12 47.4782
R162 VDD.n5 VDD.t0 11.212
R163 VDD.n3 VDD.t10 11.212
R164 VDD.n2 VDD.n0 7.65437
R165 VDD.n5 VDD.t1 7.34722
R166 VDD.n4 VDD.t11 7.27008
R167 VDD.n7 VDD.n6 7.14008
R168 VDD.n9 VDD.n8 7.14008
R169 VDD.n2 VDD.n1 7.14008
R170 VDD VDD.n4 2.60407
R171 VDD VDD.n9 1.18979
R172 VDD.n9 VDD.n7 0.514786
R173 VDD.n3 VDD.n2 0.334786
R174 VDD.n7 VDD.n5 0.334786
R175 VDD.n6 VDD.t5 0.1305
R176 VDD.n6 VDD.t3 0.1305
R177 VDD.n8 VDD.t9 0.1305
R178 VDD.n8 VDD.t7 0.1305
R179 VDD.n1 VDD.t15 0.1305
R180 VDD.n1 VDD.t13 0.1305
R181 VDD.n0 VDD.t19 0.1305
R182 VDD.n0 VDD.t17 0.1305
R183 VDD.n4 VDD.n3 0.0776429
R184 GND.n1 GND.t10 862.245
R185 GND.t9 GND.n1 862.245
R186 GND.t19 GND.n0 323.325
R187 GND GND.t0 320.079
R188 GND.t18 GND.t19 176.871
R189 GND.t17 GND.t18 176.871
R190 GND.t16 GND.t17 176.871
R191 GND.t15 GND.t16 176.871
R192 GND.t14 GND.t15 176.871
R193 GND.t13 GND.t14 176.871
R194 GND.t12 GND.t13 176.871
R195 GND.t11 GND.t12 176.871
R196 GND.t10 GND.t11 176.871
R197 GND.t8 GND.t9 176.871
R198 GND.t7 GND.t8 176.871
R199 GND.t6 GND.t7 176.871
R200 GND.t5 GND.t6 176.871
R201 GND.t4 GND.t5 176.871
R202 GND.t3 GND.t4 176.871
R203 GND.t2 GND.t3 176.871
R204 GND.t1 GND.t2 176.871
R205 GND.t0 GND.t1 176.871
R206 GND.n1 GND.n0 9.78339
R207 GND GND.n0 3.24693
C6 ISS GND 3.00198f
C7 OUT_p GND 8.134f
C8 OUT_n GND 8.22586f
C9 VDD GND 30.12546f
C10 VDD.t19 GND 0.10495f $ **FLOATING
C11 VDD.t17 GND 0.10495f $ **FLOATING
C12 VDD.n0 GND 0.3758f $ **FLOATING
C13 VDD.t15 GND 0.10495f $ **FLOATING
C14 VDD.t13 GND 0.10495f $ **FLOATING
C15 VDD.n1 GND 0.37225f $ **FLOATING
C16 VDD.n2 GND 0.09194f $ **FLOATING
C17 VDD.t18 GND 2.42915f $ **FLOATING
C18 VDD.t16 GND 0.77733f $ **FLOATING
C19 VDD.t14 GND 0.77733f $ **FLOATING
C20 VDD.t12 GND 0.77733f $ **FLOATING
C21 VDD.t10 GND 2.42659f $ **FLOATING
C22 VDD.n3 GND 0.04647f $ **FLOATING
C23 VDD.t11 GND 0.51019f $ **FLOATING
C24 VDD.n4 GND 0.09613f $ **FLOATING
C25 VDD.t1 GND 0.51057f $ **FLOATING
C26 VDD.t8 GND 2.42915f $ **FLOATING
C27 VDD.t6 GND 0.77733f $ **FLOATING
C28 VDD.t4 GND 0.77733f $ **FLOATING
C29 VDD.t2 GND 0.77733f $ **FLOATING
C30 VDD.t0 GND 2.42659f $ **FLOATING
C31 VDD.n5 GND 0.08232f $ **FLOATING
C32 VDD.t5 GND 0.10495f $ **FLOATING
C33 VDD.t3 GND 0.10495f $ **FLOATING
C34 VDD.n6 GND 0.37225f $ **FLOATING
C35 VDD.n7 GND 0.04274f $ **FLOATING
C36 VDD.t9 GND 0.10495f $ **FLOATING
C37 VDD.t7 GND 0.10495f $ **FLOATING
C38 VDD.n8 GND 0.37225f $ **FLOATING
C39 VDD.n9 GND 0.06421f $ **FLOATING
C40 OUT_n.t14 GND 0.26174f $ **FLOATING
C41 OUT_n.t13 GND 0.26174f $ **FLOATING
C42 OUT_n.n0 GND 0.93685f $ **FLOATING
C43 OUT_n.t12 GND 0.26174f $ **FLOATING
C44 OUT_n.t0 GND 0.26174f $ **FLOATING
C45 OUT_n.n1 GND 0.92839f $ **FLOATING
C46 OUT_n.n2 GND 0.23532f $ **FLOATING
C47 OUT_n.t11 GND 1.2724f $ **FLOATING
C48 OUT_n.n3 GND 0.37475f $ **FLOATING
C49 OUT_n.t2 GND 0.07478f $ **FLOATING
C50 OUT_n.t1 GND 0.07478f $ **FLOATING
C51 OUT_n.n4 GND 0.31889f $ **FLOATING
C52 OUT_n.t4 GND 0.07478f $ **FLOATING
C53 OUT_n.t3 GND 0.07478f $ **FLOATING
C54 OUT_n.n5 GND 0.31048f $ **FLOATING
C55 OUT_n.n6 GND 0.20611f $ **FLOATING
C56 OUT_n.t6 GND 0.07478f $ **FLOATING
C57 OUT_n.t5 GND 0.07478f $ **FLOATING
C58 OUT_n.n7 GND 0.31048f $ **FLOATING
C59 OUT_n.n8 GND 0.10323f $ **FLOATING
C60 OUT_n.t8 GND 0.07478f $ **FLOATING
C61 OUT_n.t7 GND 0.07478f $ **FLOATING
C62 OUT_n.n9 GND 0.31048f $ **FLOATING
C63 OUT_n.n10 GND 0.10323f $ **FLOATING
C64 OUT_n.t10 GND 0.07478f $ **FLOATING
C65 OUT_n.t9 GND 0.07478f $ **FLOATING
C66 OUT_n.n11 GND 0.31048f $ **FLOATING
C67 OUT_n.n12 GND 0.24722f $ **FLOATING
C68 OUT_n.t29 GND 0.41396f $ **FLOATING
C69 OUT_n.t28 GND 0.41396f $ **FLOATING
C70 OUT_n.t27 GND 0.41396f $ **FLOATING
C71 OUT_n.t26 GND 0.41396f $ **FLOATING
C72 OUT_n.t25 GND 0.43411f $ **FLOATING
C73 OUT_n.n13 GND 0.31378f $ **FLOATING
C74 OUT_n.n14 GND 0.17108f $ **FLOATING
C75 OUT_n.n15 GND 0.17108f $ **FLOATING
C76 OUT_n.n16 GND 0.24294f $ **FLOATING
C77 OUT_n.t15 GND 0.14307f $ **FLOATING
C78 OUT_n.t16 GND 0.12987f $ **FLOATING
C79 OUT_n.n17 GND 0.13671f $ **FLOATING
C80 OUT_n.t17 GND 0.12987f $ **FLOATING
C81 OUT_n.n18 GND 0.07907f $ **FLOATING
C82 OUT_n.t18 GND 0.12987f $ **FLOATING
C83 OUT_n.n19 GND 0.07907f $ **FLOATING
C84 OUT_n.t19 GND 0.12987f $ **FLOATING
C85 OUT_n.n20 GND 0.07907f $ **FLOATING
C86 OUT_n.t20 GND 0.12987f $ **FLOATING
C87 OUT_n.n21 GND 0.07907f $ **FLOATING
C88 OUT_n.t21 GND 0.12987f $ **FLOATING
C89 OUT_n.n22 GND 0.07907f $ **FLOATING
C90 OUT_n.t22 GND 0.12987f $ **FLOATING
C91 OUT_n.n23 GND 0.07907f $ **FLOATING
C92 OUT_n.t23 GND 0.12987f $ **FLOATING
C93 OUT_n.n24 GND 0.07907f $ **FLOATING
C94 OUT_n.t24 GND 0.12987f $ **FLOATING
C95 OUT_n.n25 GND 0.14692f $ **FLOATING
C96 OUT_n.n26 GND 2.14974f $ **FLOATING
C97 OUT_n.n27 GND 1.18245f $ **FLOATING
C98 OUT_p.t5 GND 1.31057f $ **FLOATING
C99 OUT_p.t7 GND 0.26803f $ **FLOATING
C100 OUT_p.t4 GND 0.26803f $ **FLOATING
C101 OUT_p.n0 GND 0.95071f $ **FLOATING
C102 OUT_p.n1 GND 0.22791f $ **FLOATING
C103 OUT_p.t1 GND 0.26803f $ **FLOATING
C104 OUT_p.t2 GND 0.26803f $ **FLOATING
C105 OUT_p.n2 GND 0.95071f $ **FLOATING
C106 OUT_p.n3 GND 0.41349f $ **FLOATING
C107 OUT_p.t10 GND 0.07658f $ **FLOATING
C108 OUT_p.t14 GND 0.07658f $ **FLOATING
C109 OUT_p.n4 GND 0.32655f $ **FLOATING
C110 OUT_p.t6 GND 0.07658f $ **FLOATING
C111 OUT_p.t9 GND 0.07658f $ **FLOATING
C112 OUT_p.n5 GND 0.31794f $ **FLOATING
C113 OUT_p.n6 GND 0.21107f $ **FLOATING
C114 OUT_p.t13 GND 0.07658f $ **FLOATING
C115 OUT_p.t3 GND 0.07658f $ **FLOATING
C116 OUT_p.n7 GND 0.31794f $ **FLOATING
C117 OUT_p.n8 GND 0.10571f $ **FLOATING
C118 OUT_p.t0 GND 0.07658f $ **FLOATING
C119 OUT_p.t11 GND 0.07658f $ **FLOATING
C120 OUT_p.n9 GND 0.31794f $ **FLOATING
C121 OUT_p.n10 GND 0.10571f $ **FLOATING
C122 OUT_p.t8 GND 0.07658f $ **FLOATING
C123 OUT_p.t12 GND 0.07658f $ **FLOATING
C124 OUT_p.n11 GND 0.31794f $ **FLOATING
C125 OUT_p.n12 GND 0.24009f $ **FLOATING
C126 OUT_p.t29 GND 0.42391f $ **FLOATING
C127 OUT_p.t28 GND 0.42391f $ **FLOATING
C128 OUT_p.t27 GND 0.42391f $ **FLOATING
C129 OUT_p.t26 GND 0.42391f $ **FLOATING
C130 OUT_p.t25 GND 0.44455f $ **FLOATING
C131 OUT_p.n13 GND 0.32133f $ **FLOATING
C132 OUT_p.n14 GND 0.17519f $ **FLOATING
C133 OUT_p.n15 GND 0.17519f $ **FLOATING
C134 OUT_p.n16 GND 0.24938f $ **FLOATING
C135 OUT_p.t15 GND 0.1465f $ **FLOATING
C136 OUT_p.t16 GND 0.13299f $ **FLOATING
C137 OUT_p.n17 GND 0.14f $ **FLOATING
C138 OUT_p.t17 GND 0.13299f $ **FLOATING
C139 OUT_p.n18 GND 0.08097f $ **FLOATING
C140 OUT_p.t18 GND 0.13299f $ **FLOATING
C141 OUT_p.n19 GND 0.08097f $ **FLOATING
C142 OUT_p.t19 GND 0.13299f $ **FLOATING
C143 OUT_p.n20 GND 0.08097f $ **FLOATING
C144 OUT_p.t20 GND 0.13299f $ **FLOATING
C145 OUT_p.n21 GND 0.08097f $ **FLOATING
C146 OUT_p.t21 GND 0.13299f $ **FLOATING
C147 OUT_p.n22 GND 0.08097f $ **FLOATING
C148 OUT_p.t22 GND 0.13299f $ **FLOATING
C149 OUT_p.n23 GND 0.08097f $ **FLOATING
C150 OUT_p.t23 GND 0.13299f $ **FLOATING
C151 OUT_p.n24 GND 0.08097f $ **FLOATING
C152 OUT_p.t24 GND 0.13299f $ **FLOATING
C153 OUT_p.n25 GND 0.13661f $ **FLOATING
C154 OUT_p.n26 GND 2.06991f $ **FLOATING
C155 OUT_p.n27 GND 1.06416f $ **FLOATING
C156 ISS.t9 GND 0.46281f $ **FLOATING
C157 ISS.t7 GND 0.08571f $ **FLOATING
C158 ISS.t5 GND 0.08571f $ **FLOATING
C159 ISS.n0 GND 0.35583f $ **FLOATING
C160 ISS.n1 GND 0.27555f $ **FLOATING
C161 ISS.t16 GND 0.08571f $ **FLOATING
C162 ISS.t8 GND 0.08571f $ **FLOATING
C163 ISS.n2 GND 0.35583f $ **FLOATING
C164 ISS.n3 GND 0.11831f $ **FLOATING
C165 ISS.t6 GND 0.08571f $ **FLOATING
C166 ISS.t4 GND 0.08571f $ **FLOATING
C167 ISS.n4 GND 0.35583f $ **FLOATING
C168 ISS.n5 GND 0.11831f $ **FLOATING
C169 ISS.t15 GND 0.08571f $ **FLOATING
C170 ISS.t1 GND 0.08571f $ **FLOATING
C171 ISS.n6 GND 0.35583f $ **FLOATING
C172 ISS.n7 GND 0.11831f $ **FLOATING
C173 ISS.t2 GND 0.45074f $ **FLOATING
C174 ISS.n8 GND 0.26668f $ **FLOATING
C175 ISS.t13 GND 0.45074f $ **FLOATING
C176 ISS.n9 GND 0.2436f $ **FLOATING
C177 ISS.t17 GND 0.46281f $ **FLOATING
C178 ISS.t14 GND 0.08571f $ **FLOATING
C179 ISS.t11 GND 0.08571f $ **FLOATING
C180 ISS.n10 GND 0.35583f $ **FLOATING
C181 ISS.n11 GND 0.27555f $ **FLOATING
C182 ISS.t3 GND 0.08571f $ **FLOATING
C183 ISS.t0 GND 0.08571f $ **FLOATING
C184 ISS.n12 GND 0.35583f $ **FLOATING
C185 ISS.n13 GND 0.11831f $ **FLOATING
C186 ISS.t12 GND 0.08571f $ **FLOATING
C187 ISS.t18 GND 0.08571f $ **FLOATING
C188 ISS.n14 GND 0.35583f $ **FLOATING
C189 ISS.n15 GND 0.11831f $ **FLOATING
C190 ISS.t19 GND 0.08571f $ **FLOATING
C191 ISS.t10 GND 0.08571f $ **FLOATING
C192 ISS.n16 GND 0.35583f $ **FLOATING
C193 ISS.n17 GND 0.10447f $ **FLOATING
